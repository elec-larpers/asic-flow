* NGSPICE file created from yolo26n_top.ext - technology: sky130A

* Black-box entry subcircuit for sky130_fd_sc_hd__fill_1 abstract view
.subckt sky130_fd_sc_hd__fill_1 VGND VNB VPB VPWR
.ends

* Black-box entry subcircuit for sky130_fd_sc_hd__tapvpwrvgnd_1 abstract view
.subckt sky130_fd_sc_hd__tapvpwrvgnd_1 VGND VPWR
.ends

* Black-box entry subcircuit for sky130_fd_sc_hd__decap_6 abstract view
.subckt sky130_fd_sc_hd__decap_6 VGND VNB VPB VPWR
.ends

* Black-box entry subcircuit for sky130_ef_sc_hd__decap_12 abstract view
.subckt sky130_ef_sc_hd__decap_12 VPWR VGND VPB VNB
.ends

* Black-box entry subcircuit for sky130_fd_sc_hd__fill_2 abstract view
.subckt sky130_fd_sc_hd__fill_2 VGND VNB VPB VPWR
.ends

* Black-box entry subcircuit for sky130_fd_sc_hd__decap_3 abstract view
.subckt sky130_fd_sc_hd__decap_3 VGND VNB VPB VPWR
.ends

* Black-box entry subcircuit for sky130_fd_sc_hd__a21bo_1 abstract view
.subckt sky130_fd_sc_hd__a21bo_1 A1 A2 B1_N VGND VNB VPB VPWR X
.ends

* Black-box entry subcircuit for sky130_fd_sc_hd__mux2_1 abstract view
.subckt sky130_fd_sc_hd__mux2_1 A0 A1 S VGND VNB VPB VPWR X
.ends

* Black-box entry subcircuit for sky130_fd_sc_hd__a221o_1 abstract view
.subckt sky130_fd_sc_hd__a221o_1 A1 A2 B1 B2 C1 VGND VNB VPB VPWR X
.ends

* Black-box entry subcircuit for sky130_fd_sc_hd__decap_8 abstract view
.subckt sky130_fd_sc_hd__decap_8 VGND VNB VPB VPWR
.ends

* Black-box entry subcircuit for sky130_fd_sc_hd__a21o_1 abstract view
.subckt sky130_fd_sc_hd__a21o_1 A1 A2 B1 VGND VNB VPB VPWR X
.ends

* Black-box entry subcircuit for sky130_fd_sc_hd__a21oi_1 abstract view
.subckt sky130_fd_sc_hd__a21oi_1 A1 A2 B1 VGND VNB VPB VPWR Y
.ends

* Black-box entry subcircuit for sky130_fd_sc_hd__clkbuf_4 abstract view
.subckt sky130_fd_sc_hd__clkbuf_4 A VGND VNB VPB VPWR X
.ends

* Black-box entry subcircuit for sky130_fd_sc_hd__a22o_1 abstract view
.subckt sky130_fd_sc_hd__a22o_1 A1 A2 B1 B2 VGND VNB VPB VPWR X
.ends

* Black-box entry subcircuit for sky130_fd_sc_hd__buf_2 abstract view
.subckt sky130_fd_sc_hd__buf_2 A VGND VNB VPB VPWR X
.ends

* Black-box entry subcircuit for sky130_fd_sc_hd__clkbuf_2 abstract view
.subckt sky130_fd_sc_hd__clkbuf_2 A VGND VNB VPB VPWR X
.ends

* Black-box entry subcircuit for sky130_fd_sc_hd__or3b_1 abstract view
.subckt sky130_fd_sc_hd__or3b_1 A B C_N VGND VNB VPB VPWR X
.ends

* Black-box entry subcircuit for sky130_fd_sc_hd__a21boi_1 abstract view
.subckt sky130_fd_sc_hd__a21boi_1 A1 A2 B1_N VGND VNB VPB VPWR Y
.ends

* Black-box entry subcircuit for sky130_fd_sc_hd__and3_1 abstract view
.subckt sky130_fd_sc_hd__and3_1 A B C VGND VNB VPB VPWR X
.ends

* Black-box entry subcircuit for sky130_fd_sc_hd__decap_4 abstract view
.subckt sky130_fd_sc_hd__decap_4 VGND VNB VPB VPWR
.ends

* Black-box entry subcircuit for sky130_fd_sc_hd__dfxtp_1 abstract view
.subckt sky130_fd_sc_hd__dfxtp_1 CLK D VGND VNB VPB VPWR Q
.ends

* Black-box entry subcircuit for sky130_fd_sc_hd__or2_1 abstract view
.subckt sky130_fd_sc_hd__or2_1 A B VGND VNB VPB VPWR X
.ends

* Black-box entry subcircuit for sky130_fd_sc_hd__clkbuf_8 abstract view
.subckt sky130_fd_sc_hd__clkbuf_8 A VGND VNB VPB VPWR X
.ends

* Black-box entry subcircuit for sky130_fd_sc_hd__dlygate4sd3_1 abstract view
.subckt sky130_fd_sc_hd__dlygate4sd3_1 A VGND VNB VPB VPWR X
.ends

* Black-box entry subcircuit for sky130_fd_sc_hd__diode_2 abstract view
.subckt sky130_fd_sc_hd__diode_2 DIODE VGND VNB VPB VPWR
.ends

* Black-box entry subcircuit for sky130_fd_sc_hd__o211a_1 abstract view
.subckt sky130_fd_sc_hd__o211a_1 A1 A2 B1 C1 VGND VNB VPB VPWR X
.ends

* Black-box entry subcircuit for sky130_fd_sc_hd__nand2_1 abstract view
.subckt sky130_fd_sc_hd__nand2_1 A B VGND VNB VPB VPWR Y
.ends

* Black-box entry subcircuit for sky130_fd_sc_hd__mux4_1 abstract view
.subckt sky130_fd_sc_hd__mux4_1 A0 A1 A2 A3 S0 S1 VGND VNB VPB VPWR X
.ends

* Black-box entry subcircuit for sky130_fd_sc_hd__o21ai_1 abstract view
.subckt sky130_fd_sc_hd__o21ai_1 A1 A2 B1 VGND VNB VPB VPWR Y
.ends

* Black-box entry subcircuit for sky130_fd_sc_hd__nand4_1 abstract view
.subckt sky130_fd_sc_hd__nand4_1 A B C D VGND VNB VPB VPWR Y
.ends

* Black-box entry subcircuit for sky130_fd_sc_hd__clkbuf_16 abstract view
.subckt sky130_fd_sc_hd__clkbuf_16 A VGND VNB VPB VPWR X
.ends

* Black-box entry subcircuit for sky130_fd_sc_hd__and4_1 abstract view
.subckt sky130_fd_sc_hd__and4_1 A B C D VGND VNB VPB VPWR X
.ends

* Black-box entry subcircuit for sky130_fd_sc_hd__o2bb2a_1 abstract view
.subckt sky130_fd_sc_hd__o2bb2a_1 A1_N A2_N B1 B2 VGND VNB VPB VPWR X
.ends

* Black-box entry subcircuit for sky130_fd_sc_hd__and2_1 abstract view
.subckt sky130_fd_sc_hd__and2_1 A B VGND VNB VPB VPWR X
.ends

* Black-box entry subcircuit for sky130_fd_sc_hd__nor2_1 abstract view
.subckt sky130_fd_sc_hd__nor2_1 A B VGND VNB VPB VPWR Y
.ends

* Black-box entry subcircuit for sky130_fd_sc_hd__nand3_1 abstract view
.subckt sky130_fd_sc_hd__nand3_1 A B C VGND VNB VPB VPWR Y
.ends

* Black-box entry subcircuit for sky130_fd_sc_hd__nor3b_1 abstract view
.subckt sky130_fd_sc_hd__nor3b_1 A B C_N VGND VNB VPB VPWR Y
.ends

* Black-box entry subcircuit for sky130_fd_sc_hd__clkinvlp_4 abstract view
.subckt sky130_fd_sc_hd__clkinvlp_4 A VGND VNB VPB VPWR Y
.ends

* Black-box entry subcircuit for sky130_fd_sc_hd__a31o_1 abstract view
.subckt sky130_fd_sc_hd__a31o_1 A1 A2 A3 B1 VGND VNB VPB VPWR X
.ends

* Black-box entry subcircuit for sky130_fd_sc_hd__bufinv_16 abstract view
.subckt sky130_fd_sc_hd__bufinv_16 A VGND VNB VPB VPWR Y
.ends

* Black-box entry subcircuit for sky130_fd_sc_hd__inv_8 abstract view
.subckt sky130_fd_sc_hd__inv_8 A VGND VNB VPB VPWR Y
.ends

* Black-box entry subcircuit for sky130_fd_sc_hd__clkinv_2 abstract view
.subckt sky130_fd_sc_hd__clkinv_2 A VGND VNB VPB VPWR Y
.ends

* Black-box entry subcircuit for sky130_fd_sc_hd__dlymetal6s2s_1 abstract view
.subckt sky130_fd_sc_hd__dlymetal6s2s_1 A VGND VNB VPB VPWR X
.ends

* Black-box entry subcircuit for sky130_fd_sc_hd__or3_1 abstract view
.subckt sky130_fd_sc_hd__or3_1 A B C VGND VNB VPB VPWR X
.ends

* Black-box entry subcircuit for sky130_fd_sc_hd__o221a_1 abstract view
.subckt sky130_fd_sc_hd__o221a_1 A1 A2 B1 B2 C1 VGND VNB VPB VPWR X
.ends

* Black-box entry subcircuit for sky130_fd_sc_hd__inv_6 abstract view
.subckt sky130_fd_sc_hd__inv_6 A VGND VNB VPB VPWR Y
.ends

* Black-box entry subcircuit for sky130_fd_sc_hd__buf_1 abstract view
.subckt sky130_fd_sc_hd__buf_1 A VGND VNB VPB VPWR X
.ends

* Black-box entry subcircuit for sky130_fd_sc_hd__inv_2 abstract view
.subckt sky130_fd_sc_hd__inv_2 A VGND VNB VPB VPWR Y
.ends

* Black-box entry subcircuit for sky130_fd_sc_hd__nor3_1 abstract view
.subckt sky130_fd_sc_hd__nor3_1 A B C VGND VNB VPB VPWR Y
.ends

* Black-box entry subcircuit for sky130_fd_sc_hd__and4b_1 abstract view
.subckt sky130_fd_sc_hd__and4b_1 A_N B C D VGND VNB VPB VPWR X
.ends

* Black-box entry subcircuit for sky130_fd_sc_hd__or4_1 abstract view
.subckt sky130_fd_sc_hd__or4_1 A B C D VGND VNB VPB VPWR X
.ends

* Black-box entry subcircuit for sky130_fd_sc_hd__a32o_1 abstract view
.subckt sky130_fd_sc_hd__a32o_1 A1 A2 A3 B1 B2 VGND VNB VPB VPWR X
.ends

* Black-box entry subcircuit for sky130_fd_sc_hd__a31o_2 abstract view
.subckt sky130_fd_sc_hd__a31o_2 A1 A2 A3 B1 VGND VNB VPB VPWR X
.ends

* Black-box entry subcircuit for sky130_fd_sc_hd__a31oi_1 abstract view
.subckt sky130_fd_sc_hd__a31oi_1 A1 A2 A3 B1 VGND VNB VPB VPWR Y
.ends

* Black-box entry subcircuit for sky130_fd_sc_hd__o311a_1 abstract view
.subckt sky130_fd_sc_hd__o311a_1 A1 A2 A3 B1 C1 VGND VNB VPB VPWR X
.ends

* Black-box entry subcircuit for sky130_fd_sc_hd__and3b_1 abstract view
.subckt sky130_fd_sc_hd__and3b_1 A_N B C VGND VNB VPB VPWR X
.ends

* Black-box entry subcircuit for sky130_fd_sc_hd__clkbuf_1 abstract view
.subckt sky130_fd_sc_hd__clkbuf_1 A VGND VNB VPB VPWR X
.ends

* Black-box entry subcircuit for sky130_fd_sc_hd__and2b_1 abstract view
.subckt sky130_fd_sc_hd__and2b_1 A_N B VGND VNB VPB VPWR X
.ends

* Black-box entry subcircuit for sky130_fd_sc_hd__a21oi_4 abstract view
.subckt sky130_fd_sc_hd__a21oi_4 A1 A2 B1 VGND VNB VPB VPWR Y
.ends

* Black-box entry subcircuit for sky130_fd_sc_hd__and4_2 abstract view
.subckt sky130_fd_sc_hd__and4_2 A B C D VGND VNB VPB VPWR X
.ends

* Black-box entry subcircuit for sky130_fd_sc_hd__and4bb_1 abstract view
.subckt sky130_fd_sc_hd__and4bb_1 A_N B_N C D VGND VNB VPB VPWR X
.ends

* Black-box entry subcircuit for sky130_fd_sc_hd__o21a_1 abstract view
.subckt sky130_fd_sc_hd__o21a_1 A1 A2 B1 VGND VNB VPB VPWR X
.ends

* Black-box entry subcircuit for sky130_fd_sc_hd__o21ba_1 abstract view
.subckt sky130_fd_sc_hd__o21ba_1 A1 A2 B1_N VGND VNB VPB VPWR X
.ends

* Black-box entry subcircuit for sky130_fd_sc_hd__or4b_1 abstract view
.subckt sky130_fd_sc_hd__or4b_1 A B C D_N VGND VNB VPB VPWR X
.ends

* Black-box entry subcircuit for sky130_fd_sc_hd__o21bai_1 abstract view
.subckt sky130_fd_sc_hd__o21bai_1 A1 A2 B1_N VGND VNB VPB VPWR Y
.ends

* Black-box entry subcircuit for sky130_fd_sc_hd__a41o_1 abstract view
.subckt sky130_fd_sc_hd__a41o_1 A1 A2 A3 A4 B1 VGND VNB VPB VPWR X
.ends

* Black-box entry subcircuit for sky130_fd_sc_hd__o22a_1 abstract view
.subckt sky130_fd_sc_hd__o22a_1 A1 A2 B1 B2 VGND VNB VPB VPWR X
.ends

* Black-box entry subcircuit for sky130_fd_sc_hd__o32a_1 abstract view
.subckt sky130_fd_sc_hd__o32a_1 A1 A2 A3 B1 B2 VGND VNB VPB VPWR X
.ends

* Black-box entry subcircuit for sky130_fd_sc_hd__xnor2_1 abstract view
.subckt sky130_fd_sc_hd__xnor2_1 A B VGND VNB VPB VPWR Y
.ends

* Black-box entry subcircuit for sky130_fd_sc_hd__or4_2 abstract view
.subckt sky130_fd_sc_hd__or4_2 A B C D VGND VNB VPB VPWR X
.ends

* Black-box entry subcircuit for sky130_fd_sc_hd__or4b_4 abstract view
.subckt sky130_fd_sc_hd__or4b_4 A B C D_N VGND VNB VPB VPWR X
.ends

* Black-box entry subcircuit for sky130_fd_sc_hd__a211o_1 abstract view
.subckt sky130_fd_sc_hd__a211o_1 A1 A2 B1 C1 VGND VNB VPB VPWR X
.ends

.subckt yolo26n_top VGND VPWR busy clock current_stage[0] current_stage[1] current_stage[2]
+ current_stage[3] current_stage[4] done host_input_addr[0] host_input_addr[10] host_input_addr[11]
+ host_input_addr[12] host_input_addr[13] host_input_addr[14] host_input_addr[15]
+ host_input_addr[16] host_input_addr[17] host_input_addr[18] host_input_addr[19]
+ host_input_addr[1] host_input_addr[20] host_input_addr[2] host_input_addr[3] host_input_addr[4]
+ host_input_addr[5] host_input_addr[6] host_input_addr[7] host_input_addr[8] host_input_addr[9]
+ host_input_data[0] host_input_data[10] host_input_data[11] host_input_data[12] host_input_data[13]
+ host_input_data[14] host_input_data[15] host_input_data[16] host_input_data[17]
+ host_input_data[18] host_input_data[19] host_input_data[1] host_input_data[20] host_input_data[21]
+ host_input_data[22] host_input_data[23] host_input_data[24] host_input_data[25]
+ host_input_data[26] host_input_data[27] host_input_data[28] host_input_data[29]
+ host_input_data[2] host_input_data[30] host_input_data[31] host_input_data[3] host_input_data[4]
+ host_input_data[5] host_input_data[6] host_input_data[7] host_input_data[8] host_input_data[9]
+ host_input_we host_output_addr[0] host_output_addr[10] host_output_addr[1] host_output_addr[2]
+ host_output_addr[3] host_output_addr[4] host_output_addr[5] host_output_addr[6]
+ host_output_addr[7] host_output_addr[8] host_output_addr[9] host_output_data[0]
+ host_output_data[10] host_output_data[11] host_output_data[12] host_output_data[13]
+ host_output_data[14] host_output_data[15] host_output_data[16] host_output_data[17]
+ host_output_data[18] host_output_data[19] host_output_data[1] host_output_data[20]
+ host_output_data[21] host_output_data[22] host_output_data[23] host_output_data[24]
+ host_output_data[25] host_output_data[26] host_output_data[27] host_output_data[28]
+ host_output_data[29] host_output_data[2] host_output_data[30] host_output_data[31]
+ host_output_data[3] host_output_data[4] host_output_data[5] host_output_data[6]
+ host_output_data[7] host_output_data[8] host_output_data[9] reset start
XFILLER_54_203 VGND VGND VPWR VPWR sky130_fd_sc_hd__fill_1
XTAP_TAPCELL_ROW_37_456 VGND VPWR sky130_fd_sc_hd__tapvpwrvgnd_1
XFILLER_52_29 VGND VGND VPWR VPWR sky130_fd_sc_hd__decap_6
XFILLER_52_18 VGND VGND VPWR VPWR sky130_fd_sc_hd__fill_1
XTAP_TAPCELL_ROW_20_323 VGND VPWR sky130_fd_sc_hd__tapvpwrvgnd_1
XFILLER_18_406 VPWR VGND VPWR VGND sky130_ef_sc_hd__decap_12
XTAP_TAPCELL_ROW_71_735 VGND VPWR sky130_fd_sc_hd__tapvpwrvgnd_1
XFILLER_60_239 VGND VGND VPWR VPWR sky130_fd_sc_hd__decap_6
XFILLER_45_225 VPWR VGND VPWR VGND sky130_ef_sc_hd__decap_12
XFILLER_26_52 VGND VGND VPWR VPWR sky130_fd_sc_hd__fill_2
XFILLER_13_111 VGND VGND VPWR VPWR sky130_fd_sc_hd__fill_1
XFILLER_13_166 VGND VGND VPWR VPWR sky130_fd_sc_hd__fill_2
XFILLER_13_177 VGND VGND VPWR VPWR sky130_fd_sc_hd__decap_3
XFILLER_13_199 VGND VGND VPWR VPWR sky130_fd_sc_hd__decap_6
X_1270_ net25 net166 _0313_ VGND VGND VPWR VPWR _0141_ sky130_fd_sc_hd__a21bo_1
XFILLER_67_81 VPWR VGND VPWR VGND sky130_ef_sc_hd__decap_12
XFILLER_24_409 VGND VGND VPWR VPWR sky130_fd_sc_hd__fill_2
XTAP_TAPCELL_ROW_34_437 VGND VPWR sky130_fd_sc_hd__tapvpwrvgnd_1
X_1606_ net35 _0534_ net141 VGND VGND VPWR VPWR _0535_ sky130_fd_sc_hd__mux2_1
X_0985_ scratch\[4\]\[23\] net229 net219 scratch\[5\]\[23\] net235 VGND VGND VPWR
+ VPWR _0724_ sky130_fd_sc_hd__a221o_1
XFILLER_74_309 VPWR VGND VPWR VGND sky130_ef_sc_hd__decap_12
XFILLER_59_328 VGND VGND VPWR VPWR sky130_fd_sc_hd__decap_8
X_1537_ net303 net107 _0479_ VGND VGND VPWR VPWR _0242_ sky130_fd_sc_hd__a21o_1
X_1399_ net150 _0393_ scratch\[0\]\[16\] VGND VGND VPWR VPWR _0397_ sky130_fd_sc_hd__a21oi_1
Xfanout138 net141 VGND VGND VPWR VPWR net138 sky130_fd_sc_hd__clkbuf_4
X_1468_ net48 net142 net112 net428 VGND VGND VPWR VPWR _0207_ sky130_fd_sc_hd__a22o_1
Xfanout116 _0445_ VGND VGND VPWR VPWR net116 sky130_fd_sc_hd__buf_2
Xfanout127 net131 VGND VGND VPWR VPWR net127 sky130_fd_sc_hd__buf_2
Xfanout149 _0349_ VGND VGND VPWR VPWR net149 sky130_fd_sc_hd__clkbuf_2
XFILLER_63_39 VPWR VGND VPWR VGND sky130_ef_sc_hd__decap_12
XFILLER_27_225 VPWR VGND VPWR VGND sky130_ef_sc_hd__decap_12
XFILLER_23_431 VGND VGND VPWR VPWR sky130_fd_sc_hd__fill_1
XFILLER_10_114 VGND VGND VPWR VPWR sky130_fd_sc_hd__decap_6
XFILLER_2_357 VGND VGND VPWR VPWR sky130_fd_sc_hd__decap_6
XFILLER_18_236 VGND VGND VPWR VPWR sky130_fd_sc_hd__fill_2
XFILLER_52_6 VPWR VGND VPWR VGND sky130_ef_sc_hd__decap_12
XFILLER_56_309 VPWR VGND VPWR VGND sky130_ef_sc_hd__decap_12
X_1253_ net240 net162 scratch\[7\]\[4\] VGND VGND VPWR VPWR _0305_ sky130_fd_sc_hd__or3b_1
X_1322_ net212 cycle_count\[0\] net205 VGND VGND VPWR VPWR _0341_ sky130_fd_sc_hd__a21boi_1
XTAP_TAPCELL_ROW_47_540 VGND VPWR sky130_fd_sc_hd__tapvpwrvgnd_1
X_1184_ net236 net169 scratch\[6\]\[2\] VGND VGND VPWR VPWR _0270_ sky130_fd_sc_hd__or3b_1
X_0968_ net210 _0706_ _0709_ VGND VGND VPWR VPWR net87 sky130_fd_sc_hd__and3_1
XFILLER_20_401 VPWR VGND VPWR VGND sky130_ef_sc_hd__decap_12
X_0899_ scratch\[4\]\[9\] net224 net215 scratch\[5\]\[9\] net232 VGND VGND VPWR VPWR
+ _0652_ sky130_fd_sc_hd__a221o_1
XFILLER_74_139 VGND VGND VPWR VPWR sky130_fd_sc_hd__fill_1
XFILLER_74_27 VGND VGND VPWR VPWR sky130_fd_sc_hd__fill_1
XFILLER_47_309 VPWR VGND VPWR VGND sky130_ef_sc_hd__decap_12
XFILLER_70_389 VPWR VGND VPWR VGND sky130_ef_sc_hd__decap_12
XFILLER_70_345 VPWR VGND VPWR VGND sky130_ef_sc_hd__decap_12
XFILLER_70_301 VGND VGND VPWR VPWR sky130_fd_sc_hd__decap_6
XTAP_TAPCELL_ROW_53_587 VGND VPWR sky130_fd_sc_hd__tapvpwrvgnd_1
XTAP_TAPCELL_ROW_2_176 VGND VPWR sky130_fd_sc_hd__tapvpwrvgnd_1
XFILLER_23_53 VGND VGND VPWR VPWR sky130_fd_sc_hd__decap_3
XFILLER_7_405 VPWR VGND VPWR VGND sky130_ef_sc_hd__decap_12
XFILLER_7_449 VGND VGND VPWR VPWR sky130_fd_sc_hd__decap_4
XFILLER_38_309 VPWR VGND VPWR VGND sky130_ef_sc_hd__decap_12
XFILLER_2_165 VPWR VGND VPWR VGND sky130_ef_sc_hd__decap_12
XFILLER_2_121 VPWR VGND VPWR VGND sky130_ef_sc_hd__decap_12
XFILLER_73_161 VGND VGND VPWR VPWR sky130_fd_sc_hd__decap_6
XFILLER_0_57 VPWR VGND VPWR VGND sky130_ef_sc_hd__decap_12
X_1871_ clknet_leaf_8_clock _0213_ VGND VGND VPWR VPWR scratch\[3\]\[10\] sky130_fd_sc_hd__dfxtp_1
X_0822_ net238 _0584_ VGND VGND VPWR VPWR _0585_ sky130_fd_sc_hd__or2_1
XTAP_TAPCELL_ROW_16_289 VGND VPWR sky130_fd_sc_hd__tapvpwrvgnd_1
XFILLER_56_128 VPWR VGND VPWR VGND sky130_ef_sc_hd__decap_12
X_1236_ net244 net174 scratch\[6\]\[28\] VGND VGND VPWR VPWR _0296_ sky130_fd_sc_hd__or3b_1
X_1305_ net237 net160 scratch\[7\]\[30\] VGND VGND VPWR VPWR _0331_ sky130_fd_sc_hd__or3b_1
XFILLER_64_161 VGND VGND VPWR VPWR sky130_fd_sc_hd__decap_6
X_1098_ net52 net185 net128 net329 VGND VGND VPWR VPWR _0041_ sky130_fd_sc_hd__a22o_1
XFILLER_52_301 VGND VGND VPWR VPWR sky130_fd_sc_hd__decap_6
X_1167_ net380 net123 _0806_ VGND VGND VPWR VPWR _0091_ sky130_fd_sc_hd__a21o_1
XFILLER_37_364 VGND VGND VPWR VPWR sky130_fd_sc_hd__decap_4
XFILLER_60_29 VPWR VGND VPWR VGND sky130_ef_sc_hd__decap_12
XFILLER_4_419 VGND VGND VPWR VPWR sky130_fd_sc_hd__fill_1
XFILLER_69_27 VPWR VGND VPWR VGND sky130_ef_sc_hd__decap_12
XTAP_TAPCELL_ROW_66_690 VGND VPWR sky130_fd_sc_hd__tapvpwrvgnd_1
XTAP_TAPCELL_ROW_58_624 VGND VPWR sky130_fd_sc_hd__tapvpwrvgnd_1
XFILLER_43_334 VGND VGND VPWR VPWR sky130_fd_sc_hd__fill_2
XFILLER_28_320 VGND VGND VPWR VPWR sky130_fd_sc_hd__fill_2
XFILLER_70_197 VPWR VGND VPWR VGND sky130_ef_sc_hd__decap_12
XFILLER_70_153 VPWR VGND VPWR VGND sky130_ef_sc_hd__decap_12
XFILLER_34_41 VGND VGND VPWR VPWR sky130_fd_sc_hd__fill_2
XFILLER_3_441 VGND VGND VPWR VPWR sky130_fd_sc_hd__decap_6
XFILLER_7_279 VGND VGND VPWR VPWR sky130_fd_sc_hd__fill_1
XFILLER_59_93 VPWR VGND VPWR VGND sky130_ef_sc_hd__decap_12
XFILLER_19_320 VGND VGND VPWR VPWR sky130_fd_sc_hd__fill_2
XFILLER_75_81 VGND VGND VPWR VPWR sky130_fd_sc_hd__decap_3
XTAP_TAPCELL_ROW_29_392 VGND VPWR sky130_fd_sc_hd__tapvpwrvgnd_1
X_1021_ scratch\[4\]\[29\] net222 net217 scratch\[5\]\[29\] net231 VGND VGND VPWR
+ VPWR _0754_ sky130_fd_sc_hd__a221o_1
X_1923_ clknet_leaf_24_clock _0265_ VGND VGND VPWR VPWR scratch\[1\]\[30\] sky130_fd_sc_hd__dfxtp_1
X_1854_ clknet_leaf_17_clock _0196_ VGND VGND VPWR VPWR scratch\[0\]\[25\] sky130_fd_sc_hd__dfxtp_1
Xclkbuf_leaf_19_clock clknet_2_2__leaf_clock VGND VGND VPWR VPWR clknet_leaf_19_clock
+ sky130_fd_sc_hd__clkbuf_8
X_1785_ clknet_leaf_26_clock _0128_ VGND VGND VPWR VPWR scratch\[6\]\[31\] sky130_fd_sc_hd__dfxtp_1
X_1219_ net32 net178 _0287_ VGND VGND VPWR VPWR _0116_ sky130_fd_sc_hd__a21bo_1
XTAP_TAPCELL_ROW_55_605 VGND VPWR sky130_fd_sc_hd__tapvpwrvgnd_1
XFILLER_55_18 VGND VGND VPWR VPWR sky130_fd_sc_hd__decap_3
XFILLER_29_139 VGND VGND VPWR VPWR sky130_fd_sc_hd__decap_3
XFILLER_25_301 VGND VGND VPWR VPWR sky130_fd_sc_hd__decap_8
XFILLER_71_39 VPWR VGND VPWR VGND sky130_ef_sc_hd__decap_12
XTAP_TAPCELL_ROW_63_671 VGND VPWR sky130_fd_sc_hd__tapvpwrvgnd_1
XFILLER_52_120 VGND VGND VPWR VPWR sky130_fd_sc_hd__fill_1
XFILLER_40_348 VPWR VGND VPWR VGND sky130_ef_sc_hd__decap_12
XFILLER_20_54 VGND VGND VPWR VPWR sky130_fd_sc_hd__decap_3
Xhold74 scratch\[4\]\[20\] VGND VGND VPWR VPWR net350 sky130_fd_sc_hd__dlygate4sd3_1
Xhold63 scratch\[5\]\[21\] VGND VGND VPWR VPWR net339 sky130_fd_sc_hd__dlygate4sd3_1
XFILLER_48_448 VGND VGND VPWR VPWR sky130_fd_sc_hd__decap_4
Xhold52 scratch\[5\]\[13\] VGND VGND VPWR VPWR net328 sky130_fd_sc_hd__dlygate4sd3_1
XFILLER_29_63 VPWR VGND VPWR VGND sky130_ef_sc_hd__decap_12
Xhold30 scratch\[1\]\[28\] VGND VGND VPWR VPWR net306 sky130_fd_sc_hd__dlygate4sd3_1
XFILLER_0_433 VPWR VGND VPWR VGND sky130_ef_sc_hd__decap_12
Xhold41 scratch\[4\]\[3\] VGND VGND VPWR VPWR net317 sky130_fd_sc_hd__dlygate4sd3_1
XFILLER_75_256 VGND VGND VPWR VPWR sky130_fd_sc_hd__fill_2
XFILLER_63_429 VPWR VGND VPWR VGND sky130_ef_sc_hd__decap_12
Xhold85 scratch\[5\]\[7\] VGND VGND VPWR VPWR net361 sky130_fd_sc_hd__dlygate4sd3_1
Xhold96 scratch\[4\]\[10\] VGND VGND VPWR VPWR net372 sky130_fd_sc_hd__dlygate4sd3_1
XFILLER_31_304 VPWR VGND VPWR VGND sky130_ef_sc_hd__decap_12
XFILLER_28_161 VGND VGND VPWR VPWR sky130_fd_sc_hd__decap_3
XTAP_TAPCELL_ROW_26_373 VGND VPWR sky130_fd_sc_hd__tapvpwrvgnd_1
XFILLER_16_334 VPWR VGND VPWR VGND sky130_ef_sc_hd__decap_12
XTAP_TAPCELL_ROW_18_307 VGND VPWR sky130_fd_sc_hd__tapvpwrvgnd_1
XFILLER_31_337 VGND VGND VPWR VPWR sky130_fd_sc_hd__fill_1
X_1570_ net196 _0504_ _0505_ VGND VGND VPWR VPWR _0506_ sky130_fd_sc_hd__and3_1
XFILLER_3_293 VPWR VGND VPWR VGND sky130_ef_sc_hd__decap_12
XANTENNA_5 net273 VGND VGND VPWR VPWR sky130_fd_sc_hd__diode_2
XTAP_TAPCELL_ROW_69_719 VGND VPWR sky130_fd_sc_hd__tapvpwrvgnd_1
XFILLER_19_161 VGND VGND VPWR VPWR sky130_fd_sc_hd__decap_6
XTAP_TAPCELL_ROW_60_641 VGND VPWR sky130_fd_sc_hd__tapvpwrvgnd_1
XFILLER_34_197 VGND VGND VPWR VPWR sky130_fd_sc_hd__decap_8
X_1004_ net250 _0736_ _0739_ net208 VGND VGND VPWR VPWR net93 sky130_fd_sc_hd__o211a_1
X_1768_ clknet_leaf_7_clock _0111_ VGND VGND VPWR VPWR scratch\[6\]\[14\] sky130_fd_sc_hd__dfxtp_1
X_1837_ clknet_leaf_3_clock _0179_ VGND VGND VPWR VPWR scratch\[0\]\[8\] sky130_fd_sc_hd__dfxtp_1
X_1906_ clknet_leaf_2_clock _0248_ VGND VGND VPWR VPWR scratch\[1\]\[13\] sky130_fd_sc_hd__dfxtp_1
X_1699_ clknet_leaf_8_clock _0042_ VGND VGND VPWR VPWR scratch\[5\]\[9\] sky130_fd_sc_hd__dfxtp_1
XFILLER_45_418 VGND VGND VPWR VPWR sky130_fd_sc_hd__fill_2
XFILLER_13_337 VPWR VGND VPWR VGND sky130_ef_sc_hd__decap_12
XFILLER_21_370 VGND VGND VPWR VPWR sky130_fd_sc_hd__fill_1
XFILLER_21_381 VGND VGND VPWR VPWR sky130_fd_sc_hd__decap_8
Xoutput75 net75 VGND VGND VPWR VPWR host_output_data[0] sky130_fd_sc_hd__clkbuf_4
Xoutput97 net97 VGND VGND VPWR VPWR host_output_data[2] sky130_fd_sc_hd__clkbuf_4
XFILLER_0_241 VGND VGND VPWR VPWR sky130_fd_sc_hd__decap_3
Xoutput86 net86 VGND VGND VPWR VPWR host_output_data[1] sky130_fd_sc_hd__clkbuf_4
XTAP_TAPCELL_ROW_74_755 VGND VPWR sky130_fd_sc_hd__tapvpwrvgnd_1
XFILLER_71_281 VPWR VGND VPWR VGND sky130_ef_sc_hd__decap_12
XFILLER_44_440 VGND VGND VPWR VPWR sky130_fd_sc_hd__fill_1
XFILLER_31_134 VGND VGND VPWR VPWR sky130_fd_sc_hd__decap_4
XFILLER_16_197 VGND VGND VPWR VPWR sky130_fd_sc_hd__fill_1
XFILLER_8_363 VGND VGND VPWR VPWR sky130_fd_sc_hd__fill_1
X_1622_ net280 net109 _0547_ VGND VGND VPWR VPWR _0259_ sky130_fd_sc_hd__a21o_1
X_1553_ scratch\[3\]\[11\] scratch\[2\]\[11\] VGND VGND VPWR VPWR _0492_ sky130_fd_sc_hd__nand2_1
X_1484_ net34 net146 net116 net429 VGND VGND VPWR VPWR _0223_ sky130_fd_sc_hd__a22o_1
XFILLER_39_201 VGND VGND VPWR VPWR sky130_fd_sc_hd__fill_1
XTAP_TAPCELL_ROW_37_457 VGND VPWR sky130_fd_sc_hd__tapvpwrvgnd_1
XFILLER_50_421 VPWR VGND VPWR VGND sky130_ef_sc_hd__decap_12
XTAP_TAPCELL_ROW_20_324 VGND VPWR sky130_fd_sc_hd__tapvpwrvgnd_1
XFILLER_18_418 VGND VGND VPWR VPWR sky130_fd_sc_hd__fill_2
XFILLER_45_248 VGND VGND VPWR VPWR sky130_fd_sc_hd__fill_1
XFILLER_42_85 VPWR VGND VPWR VGND sky130_ef_sc_hd__decap_12
XFILLER_3_57 VPWR VGND VPWR VGND sky130_ef_sc_hd__decap_12
XFILLER_67_93 VPWR VGND VPWR VGND sky130_ef_sc_hd__decap_12
XFILLER_44_292 VGND VGND VPWR VPWR sky130_fd_sc_hd__fill_1
X_0984_ scratch\[6\]\[23\] scratch\[7\]\[23\] net272 VGND VGND VPWR VPWR _0723_ sky130_fd_sc_hd__mux2_1
XTAP_TAPCELL_ROW_34_438 VGND VPWR sky130_fd_sc_hd__tapvpwrvgnd_1
XFILLER_32_421 VPWR VGND VPWR VGND sky130_ef_sc_hd__decap_12
X_1536_ net51 _0478_ net138 VGND VGND VPWR VPWR _0479_ sky130_fd_sc_hd__mux2_1
X_1605_ net201 _0532_ _0533_ VGND VGND VPWR VPWR _0534_ sky130_fd_sc_hd__and3_1
XFILLER_67_362 VPWR VGND VPWR VGND sky130_ef_sc_hd__decap_12
Xfanout128 net131 VGND VGND VPWR VPWR net128 sky130_fd_sc_hd__buf_2
X_1398_ net28 net156 _0396_ VGND VGND VPWR VPWR _0186_ sky130_fd_sc_hd__a21o_1
Xfanout139 net140 VGND VGND VPWR VPWR net139 sky130_fd_sc_hd__clkbuf_4
X_1467_ net47 net142 net112 net416 VGND VGND VPWR VPWR _0206_ sky130_fd_sc_hd__a22o_1
Xfanout117 net120 VGND VGND VPWR VPWR net117 sky130_fd_sc_hd__buf_2
XFILLER_35_281 VPWR VGND VPWR VGND sky130_ef_sc_hd__decap_12
XFILLER_35_270 VGND VGND VPWR VPWR sky130_fd_sc_hd__decap_8
XFILLER_27_237 VPWR VGND VPWR VGND sky130_ef_sc_hd__decap_12
XPHY_EDGE_ROW_19_Left_95 VGND VGND VPWR VPWR sky130_fd_sc_hd__decap_3
Xhold160 scratch\[3\]\[5\] VGND VGND VPWR VPWR net436 sky130_fd_sc_hd__dlygate4sd3_1
XFILLER_58_362 VGND VGND VPWR VPWR sky130_fd_sc_hd__fill_2
XFILLER_37_74 VPWR VGND VPWR VGND sky130_ef_sc_hd__decap_12
XFILLER_37_30 VPWR VGND VPWR VGND sky130_ef_sc_hd__decap_12
XFILLER_53_95 VGND VGND VPWR VPWR sky130_fd_sc_hd__fill_1
XTAP_TAPCELL_ROW_31_408 VGND VPWR sky130_fd_sc_hd__tapvpwrvgnd_1
XFILLER_14_421 VGND VGND VPWR VPWR sky130_fd_sc_hd__decap_6
XFILLER_14_432 VPWR VGND VPWR VGND sky130_ef_sc_hd__decap_12
X_1321_ net373 _0339_ _0340_ VGND VGND VPWR VPWR _0165_ sky130_fd_sc_hd__a21oi_1
XFILLER_1_391 VGND VGND VPWR VPWR sky130_fd_sc_hd__fill_1
X_1252_ net47 net159 _0304_ VGND VGND VPWR VPWR _0132_ sky130_fd_sc_hd__a21bo_1
XFILLER_64_365 VPWR VGND VPWR VGND sky130_ef_sc_hd__decap_12
XFILLER_64_354 VGND VGND VPWR VPWR sky130_fd_sc_hd__decap_8
XTAP_TAPCELL_ROW_47_541 VGND VPWR sky130_fd_sc_hd__tapvpwrvgnd_1
X_1183_ net33 net169 _0269_ VGND VGND VPWR VPWR _0098_ sky130_fd_sc_hd__a21bo_1
X_0967_ net260 _0707_ _0708_ VGND VGND VPWR VPWR _0709_ sky130_fd_sc_hd__a21o_1
XFILLER_20_413 VGND VGND VPWR VPWR sky130_fd_sc_hd__decap_6
X_0898_ scratch\[6\]\[9\] scratch\[7\]\[9\] net266 VGND VGND VPWR VPWR _0651_ sky130_fd_sc_hd__mux2_1
X_1519_ scratch\[3\]\[4\] scratch\[2\]\[4\] VGND VGND VPWR VPWR _0465_ sky130_fd_sc_hd__or2_1
XPHY_EDGE_ROW_12_Right_12 VGND VGND VPWR VPWR sky130_fd_sc_hd__decap_3
XFILLER_55_365 VGND VGND VPWR VPWR sky130_fd_sc_hd__decap_8
XTAP_TAPCELL_ROW_2_177 VGND VPWR sky130_fd_sc_hd__tapvpwrvgnd_1
XPHY_EDGE_ROW_21_Right_21 VGND VGND VPWR VPWR sky130_fd_sc_hd__decap_3
XFILLER_70_357 VGND VGND VPWR VPWR sky130_fd_sc_hd__decap_6
XTAP_TAPCELL_ROW_53_588 VGND VPWR sky130_fd_sc_hd__tapvpwrvgnd_1
XFILLER_23_21 VPWR VGND VPWR VGND sky130_ef_sc_hd__decap_12
XPHY_EDGE_ROW_30_Right_30 VGND VGND VPWR VPWR sky130_fd_sc_hd__decap_3
XFILLER_7_417 VPWR VGND VPWR VGND sky130_ef_sc_hd__decap_12
XFILLER_65_129 VGND VGND VPWR VPWR sky130_fd_sc_hd__decap_8
XFILLER_2_177 VPWR VGND VPWR VGND sky130_ef_sc_hd__decap_12
XFILLER_2_133 VGND VGND VPWR VPWR sky130_fd_sc_hd__decap_6
XFILLER_64_83 VGND VGND VPWR VPWR sky130_fd_sc_hd__fill_1
XFILLER_46_365 VPWR VGND VPWR VGND sky130_ef_sc_hd__decap_12
XFILLER_46_321 VGND VGND VPWR VPWR sky130_fd_sc_hd__decap_6
XFILLER_0_69 VPWR VGND VPWR VGND sky130_ef_sc_hd__decap_12
X_1870_ clknet_leaf_7_clock _0212_ VGND VGND VPWR VPWR scratch\[3\]\[9\] sky130_fd_sc_hd__dfxtp_1
X_0821_ cycle_count\[2\] _0583_ VGND VGND VPWR VPWR _0584_ sky130_fd_sc_hd__or2_1
X_1166_ net7 net198 net181 net28 VGND VGND VPWR VPWR _0806_ sky130_fd_sc_hd__a22o_1
X_1235_ net41 net175 _0295_ VGND VGND VPWR VPWR _0124_ sky130_fd_sc_hd__a21bo_1
X_1304_ net43 net165 _0330_ VGND VGND VPWR VPWR _0158_ sky130_fd_sc_hd__a21bo_1
XFILLER_64_184 VGND VGND VPWR VPWR sky130_fd_sc_hd__decap_4
X_1097_ net51 net185 net128 net361 VGND VGND VPWR VPWR _0040_ sky130_fd_sc_hd__a22o_1
XFILLER_20_221 VPWR VGND VPWR VGND sky130_ef_sc_hd__decap_12
XFILLER_69_39 VPWR VGND VPWR VGND sky130_ef_sc_hd__decap_12
XFILLER_75_405 VPWR VGND VPWR VGND sky130_ef_sc_hd__decap_12
XFILLER_75_449 VGND VGND VPWR VPWR sky130_fd_sc_hd__decap_4
XFILLER_70_121 VPWR VGND VPWR VGND sky130_ef_sc_hd__decap_12
XTAP_TAPCELL_ROW_66_691 VGND VPWR sky130_fd_sc_hd__tapvpwrvgnd_1
XTAP_TAPCELL_ROW_58_625 VGND VPWR sky130_fd_sc_hd__tapvpwrvgnd_1
XFILLER_43_302 VPWR VGND VPWR VGND sky130_ef_sc_hd__decap_12
XFILLER_28_387 VGND VGND VPWR VPWR sky130_fd_sc_hd__decap_8
XFILLER_28_365 VGND VGND VPWR VPWR sky130_fd_sc_hd__fill_2
XFILLER_70_165 VPWR VGND VPWR VGND sky130_ef_sc_hd__decap_12
XFILLER_50_41 VPWR VGND VPWR VGND sky130_ef_sc_hd__decap_12
XFILLER_34_75 VGND VGND VPWR VPWR sky130_fd_sc_hd__decap_8
XFILLER_34_53 VGND VGND VPWR VPWR sky130_fd_sc_hd__decap_6
XFILLER_7_225 VPWR VGND VPWR VGND sky130_ef_sc_hd__decap_12
XFILLER_11_221 VGND VGND VPWR VPWR sky130_fd_sc_hd__decap_3
XFILLER_50_85 VGND VGND VPWR VPWR sky130_fd_sc_hd__decap_8
XFILLER_38_107 VGND VGND VPWR VPWR sky130_fd_sc_hd__decap_4
X_1020_ scratch\[6\]\[29\] scratch\[7\]\[29\] net268 VGND VGND VPWR VPWR _0753_ sky130_fd_sc_hd__mux2_1
XFILLER_42_390 VPWR VGND VPWR VGND sky130_ef_sc_hd__decap_12
XTAP_TAPCELL_ROW_29_393 VGND VPWR sky130_fd_sc_hd__tapvpwrvgnd_1
X_1922_ clknet_leaf_25_clock _0264_ VGND VGND VPWR VPWR scratch\[1\]\[29\] sky130_fd_sc_hd__dfxtp_1
X_1853_ clknet_leaf_23_clock _0195_ VGND VGND VPWR VPWR scratch\[0\]\[24\] sky130_fd_sc_hd__dfxtp_1
X_1784_ clknet_leaf_26_clock _0127_ VGND VGND VPWR VPWR scratch\[6\]\[30\] sky130_fd_sc_hd__dfxtp_1
XTAP_TAPCELL_ROW_12_260 VGND VPWR sky130_fd_sc_hd__tapvpwrvgnd_1
XFILLER_57_405 VGND VGND VPWR VPWR sky130_fd_sc_hd__fill_1
XFILLER_72_419 VGND VGND VPWR VPWR sky130_fd_sc_hd__fill_1
X_1218_ net246 net178 scratch\[6\]\[19\] VGND VGND VPWR VPWR _0287_ sky130_fd_sc_hd__or3b_1
XFILLER_57_449 VGND VGND VPWR VPWR sky130_fd_sc_hd__decap_4
XTAP_TAPCELL_ROW_55_606 VGND VPWR sky130_fd_sc_hd__tapvpwrvgnd_1
X_1149_ net387 net121 _0797_ VGND VGND VPWR VPWR _0082_ sky130_fd_sc_hd__a21o_1
XFILLER_37_173 VPWR VGND VPWR VGND sky130_ef_sc_hd__decap_12
XFILLER_25_357 VGND VGND VPWR VPWR sky130_fd_sc_hd__decap_3
XFILLER_25_335 VGND VGND VPWR VPWR sky130_fd_sc_hd__fill_1
XFILLER_75_213 VGND VGND VPWR VPWR sky130_fd_sc_hd__decap_8
Xhold20 scratch\[1\]\[11\] VGND VGND VPWR VPWR net296 sky130_fd_sc_hd__dlygate4sd3_1
Xhold42 scratch\[5\]\[19\] VGND VGND VPWR VPWR net318 sky130_fd_sc_hd__dlygate4sd3_1
Xhold53 scratch\[5\]\[8\] VGND VGND VPWR VPWR net329 sky130_fd_sc_hd__dlygate4sd3_1
Xhold75 scratch\[5\]\[20\] VGND VGND VPWR VPWR net351 sky130_fd_sc_hd__dlygate4sd3_1
Xhold86 scratch\[5\]\[9\] VGND VGND VPWR VPWR net362 sky130_fd_sc_hd__dlygate4sd3_1
Xhold31 scratch\[1\]\[18\] VGND VGND VPWR VPWR net307 sky130_fd_sc_hd__dlygate4sd3_1
XFILLER_29_75 VPWR VGND VPWR VGND sky130_ef_sc_hd__decap_12
Xhold97 net73 VGND VGND VPWR VPWR net373 sky130_fd_sc_hd__dlygate4sd3_1
XFILLER_0_445 VGND VGND VPWR VPWR sky130_fd_sc_hd__decap_3
Xhold64 scratch\[4\]\[15\] VGND VGND VPWR VPWR net340 sky130_fd_sc_hd__dlygate4sd3_1
XFILLER_71_441 VGND VGND VPWR VPWR sky130_fd_sc_hd__decap_6
XFILLER_43_198 VPWR VGND VPWR VGND sky130_ef_sc_hd__decap_12
XFILLER_43_165 VGND VGND VPWR VPWR sky130_fd_sc_hd__decap_3
XFILLER_43_121 VGND VGND VPWR VPWR sky130_fd_sc_hd__fill_2
XFILLER_31_316 VGND VGND VPWR VPWR sky130_fd_sc_hd__decap_6
XFILLER_28_195 VGND VGND VPWR VPWR sky130_fd_sc_hd__fill_1
XTAP_TAPCELL_ROW_26_374 VGND VPWR sky130_fd_sc_hd__tapvpwrvgnd_1
XFILLER_16_346 VPWR VGND VPWR VGND sky130_ef_sc_hd__decap_12
XTAP_TAPCELL_ROW_18_308 VGND VPWR sky130_fd_sc_hd__tapvpwrvgnd_1
XANTENNA_6 net273 VGND VGND VPWR VPWR sky130_fd_sc_hd__diode_2
XPHY_EDGE_ROW_7_Left_83 VGND VGND VPWR VPWR sky130_fd_sc_hd__decap_3
XFILLER_3_261 VPWR VGND VPWR VGND sky130_ef_sc_hd__decap_12
XFILLER_66_246 VGND VGND VPWR VPWR sky130_fd_sc_hd__decap_6
XFILLER_54_419 VGND VGND VPWR VPWR sky130_fd_sc_hd__fill_1
X_1003_ net259 _0737_ _0738_ VGND VGND VPWR VPWR _0739_ sky130_fd_sc_hd__a21o_1
XTAP_TAPCELL_ROW_60_642 VGND VPWR sky130_fd_sc_hd__tapvpwrvgnd_1
X_1905_ clknet_leaf_8_clock _0247_ VGND VGND VPWR VPWR scratch\[1\]\[12\] sky130_fd_sc_hd__dfxtp_1
XFILLER_34_165 VPWR VGND VPWR VGND sky130_ef_sc_hd__decap_12
X_1698_ clknet_leaf_6_clock _0041_ VGND VGND VPWR VPWR scratch\[5\]\[8\] sky130_fd_sc_hd__dfxtp_1
X_1836_ clknet_leaf_5_clock _0178_ VGND VGND VPWR VPWR scratch\[0\]\[7\] sky130_fd_sc_hd__dfxtp_1
X_1767_ clknet_leaf_1_clock _0110_ VGND VGND VPWR VPWR scratch\[6\]\[13\] sky130_fd_sc_hd__dfxtp_1
XPHY_EDGE_ROW_6_Right_6 VGND VGND VPWR VPWR sky130_fd_sc_hd__decap_3
XFILLER_66_29 VPWR VGND VPWR VGND sky130_ef_sc_hd__decap_12
XFILLER_57_202 VGND VGND VPWR VPWR sky130_fd_sc_hd__fill_1
XFILLER_57_279 VGND VGND VPWR VPWR sky130_fd_sc_hd__fill_1
XFILLER_53_441 VGND VGND VPWR VPWR sky130_fd_sc_hd__decap_6
XFILLER_13_349 VPWR VGND VPWR VGND sky130_ef_sc_hd__decap_12
XFILLER_31_54 VGND VGND VPWR VPWR sky130_fd_sc_hd__fill_2
XTAP_TAPCELL_ROW_23_344 VGND VPWR sky130_fd_sc_hd__tapvpwrvgnd_1
XFILLER_21_393 VGND VGND VPWR VPWR sky130_fd_sc_hd__decap_4
Xoutput76 net76 VGND VGND VPWR VPWR host_output_data[10] sky130_fd_sc_hd__buf_2
Xoutput87 net87 VGND VGND VPWR VPWR host_output_data[20] sky130_fd_sc_hd__buf_2
Xoutput98 net98 VGND VGND VPWR VPWR host_output_data[30] sky130_fd_sc_hd__buf_2
XTAP_TAPCELL_ROW_74_756 VGND VPWR sky130_fd_sc_hd__tapvpwrvgnd_1
Xclkbuf_leaf_18_clock clknet_2_2__leaf_clock VGND VGND VPWR VPWR clknet_leaf_18_clock
+ sky130_fd_sc_hd__clkbuf_8
XFILLER_0_297 VGND VGND VPWR VPWR sky130_fd_sc_hd__decap_8
XFILLER_16_132 VGND VGND VPWR VPWR sky130_fd_sc_hd__decap_8
XFILLER_72_83 VGND VGND VPWR VPWR sky130_fd_sc_hd__fill_1
XFILLER_71_293 VPWR VGND VPWR VGND sky130_ef_sc_hd__decap_12
XPHY_EDGE_ROW_59_Right_59 VGND VGND VPWR VPWR sky130_fd_sc_hd__decap_3
XFILLER_44_452 VGND VGND VPWR VPWR sky130_fd_sc_hd__fill_1
X_1552_ net282 net108 _0491_ VGND VGND VPWR VPWR _0245_ sky130_fd_sc_hd__a21o_1
X_1621_ net38 _0546_ net139 VGND VGND VPWR VPWR _0547_ sky130_fd_sc_hd__mux2_1
XPHY_EDGE_ROW_68_Right_68 VGND VGND VPWR VPWR sky130_fd_sc_hd__decap_3
X_1483_ net32 net145 net115 net424 VGND VGND VPWR VPWR _0222_ sky130_fd_sc_hd__a22o_1
XFILLER_50_433 VGND VGND VPWR VPWR sky130_fd_sc_hd__fill_2
XFILLER_50_400 VGND VGND VPWR VPWR sky130_fd_sc_hd__decap_8
XFILLER_39_279 VGND VGND VPWR VPWR sky130_fd_sc_hd__fill_1
XTAP_TAPCELL_ROW_37_458 VGND VPWR sky130_fd_sc_hd__tapvpwrvgnd_1
XFILLER_22_113 VPWR VGND VPWR VGND sky130_ef_sc_hd__decap_12
XFILLER_22_179 VGND VGND VPWR VPWR sky130_fd_sc_hd__fill_1
XTAP_TAPCELL_ROW_20_325 VGND VPWR sky130_fd_sc_hd__tapvpwrvgnd_1
X_1819_ clknet_leaf_28_clock _0161_ VGND VGND VPWR VPWR net69 sky130_fd_sc_hd__dfxtp_1
XFILLER_45_216 VGND VGND VPWR VPWR sky130_fd_sc_hd__decap_8
XFILLER_45_205 VGND VGND VPWR VPWR sky130_fd_sc_hd__fill_2
XFILLER_41_444 VGND VGND VPWR VPWR sky130_fd_sc_hd__fill_1
XFILLER_42_97 VGND VGND VPWR VPWR sky130_fd_sc_hd__decap_6
XFILLER_3_69 VPWR VGND VPWR VGND sky130_ef_sc_hd__decap_12
XFILLER_36_205 VGND VGND VPWR VPWR sky130_fd_sc_hd__fill_1
XTAP_TAPCELL_ROW_34_439 VGND VPWR sky130_fd_sc_hd__tapvpwrvgnd_1
XFILLER_32_433 VGND VGND VPWR VPWR sky130_fd_sc_hd__fill_1
XFILLER_29_290 VPWR VGND VPWR VGND sky130_ef_sc_hd__decap_12
XFILLER_73_3 VPWR VGND VPWR VGND sky130_ef_sc_hd__decap_12
X_0983_ scratch\[0\]\[23\] scratch\[2\]\[23\] scratch\[1\]\[23\] scratch\[3\]\[23\]
+ net260 net272 VGND VGND VPWR VPWR _0722_ sky130_fd_sc_hd__mux4_1
X_1535_ net196 _0476_ _0477_ VGND VGND VPWR VPWR _0478_ sky130_fd_sc_hd__and3_1
X_1604_ scratch\[3\]\[21\] scratch\[2\]\[21\] VGND VGND VPWR VPWR _0533_ sky130_fd_sc_hd__or2_1
Xfanout129 net130 VGND VGND VPWR VPWR net129 sky130_fd_sc_hd__buf_2
Xfanout107 net108 VGND VGND VPWR VPWR net107 sky130_fd_sc_hd__clkbuf_4
Xfanout118 net120 VGND VGND VPWR VPWR net118 sky130_fd_sc_hd__buf_2
XFILLER_67_374 VPWR VGND VPWR VGND sky130_ef_sc_hd__decap_12
XFILLER_67_330 VGND VGND VPWR VPWR sky130_fd_sc_hd__decap_6
X_1397_ net119 _0391_ _0394_ VGND VGND VPWR VPWR _0396_ sky130_fd_sc_hd__and3_1
XFILLER_27_249 VPWR VGND VPWR VGND sky130_ef_sc_hd__decap_12
X_1466_ net44 net142 net112 net421 VGND VGND VPWR VPWR _0205_ sky130_fd_sc_hd__a22o_1
XFILLER_35_293 VGND VGND VPWR VPWR sky130_fd_sc_hd__decap_6
XFILLER_6_109 VPWR VGND VPWR VGND sky130_ef_sc_hd__decap_12
XFILLER_10_127 VPWR VGND VPWR VGND sky130_ef_sc_hd__decap_12
XFILLER_12_78 VGND VGND VPWR VPWR sky130_fd_sc_hd__decap_6
Xhold161 scratch\[3\]\[7\] VGND VGND VPWR VPWR net437 sky130_fd_sc_hd__dlygate4sd3_1
XFILLER_58_330 VGND VGND VPWR VPWR sky130_fd_sc_hd__decap_4
Xhold150 scratch\[3\]\[21\] VGND VGND VPWR VPWR net426 sky130_fd_sc_hd__dlygate4sd3_1
XFILLER_5_6 VPWR VGND VPWR VGND sky130_ef_sc_hd__decap_12
XFILLER_37_86 VPWR VGND VPWR VGND sky130_ef_sc_hd__decap_12
XFILLER_37_42 VPWR VGND VPWR VGND sky130_ef_sc_hd__decap_12
XFILLER_18_227 VGND VGND VPWR VPWR sky130_fd_sc_hd__fill_1
XFILLER_53_30 VGND VGND VPWR VPWR sky130_fd_sc_hd__fill_1
XFILLER_41_285 VGND VGND VPWR VPWR sky130_fd_sc_hd__fill_1
XTAP_TAPCELL_ROW_31_409 VGND VPWR sky130_fd_sc_hd__tapvpwrvgnd_1
XFILLER_14_444 VGND VGND VPWR VPWR sky130_fd_sc_hd__decap_8
X_1320_ net373 _0339_ _0333_ VGND VGND VPWR VPWR _0340_ sky130_fd_sc_hd__o21ai_1
XFILLER_38_6 VPWR VGND VPWR VGND sky130_ef_sc_hd__decap_12
X_1182_ net236 net169 scratch\[6\]\[1\] VGND VGND VPWR VPWR _0269_ sky130_fd_sc_hd__or3b_1
X_1251_ net237 net159 scratch\[7\]\[3\] VGND VGND VPWR VPWR _0304_ sky130_fd_sc_hd__or3b_1
XFILLER_64_377 VPWR VGND VPWR VGND sky130_ef_sc_hd__decap_12
XTAP_TAPCELL_ROW_47_542 VGND VPWR sky130_fd_sc_hd__tapvpwrvgnd_1
XFILLER_24_219 VGND VGND VPWR VPWR sky130_fd_sc_hd__decap_8
XPHY_EDGE_ROW_20_Left_96 VGND VGND VPWR VPWR sky130_fd_sc_hd__decap_3
X_0966_ scratch\[4\]\[20\] net229 net220 scratch\[5\]\[20\] net233 VGND VGND VPWR
+ VPWR _0708_ sky130_fd_sc_hd__a221o_1
X_0897_ scratch\[0\]\[9\] net224 _0649_ VGND VGND VPWR VPWR _0650_ sky130_fd_sc_hd__a21o_1
XFILLER_59_105 VGND VGND VPWR VPWR sky130_fd_sc_hd__decap_6
X_1518_ scratch\[3\]\[4\] scratch\[2\]\[4\] VGND VGND VPWR VPWR _0464_ sky130_fd_sc_hd__nand2_1
X_1449_ net153 _0433_ scratch\[0\]\[28\] VGND VGND VPWR VPWR _0435_ sky130_fd_sc_hd__a21oi_1
XFILLER_74_29 VPWR VGND VPWR VGND sky130_ef_sc_hd__decap_12
XTAP_TAPCELL_ROW_2_178 VGND VPWR sky130_fd_sc_hd__tapvpwrvgnd_1
XTAP_TAPCELL_ROW_53_589 VGND VPWR sky130_fd_sc_hd__tapvpwrvgnd_1
XFILLER_23_33 VPWR VGND VPWR VGND sky130_ef_sc_hd__decap_12
XFILLER_7_429 VPWR VGND VPWR VGND sky130_ef_sc_hd__decap_12
XFILLER_11_447 VGND VGND VPWR VPWR sky130_fd_sc_hd__fill_1
XFILLER_3_3 VPWR VGND VPWR VGND sky130_ef_sc_hd__decap_12
XFILLER_58_182 VGND VGND VPWR VPWR sky130_fd_sc_hd__decap_8
XFILLER_46_333 VGND VGND VPWR VPWR sky130_fd_sc_hd__decap_3
XFILLER_2_189 VGND VGND VPWR VPWR sky130_fd_sc_hd__decap_6
XFILLER_0_15 VPWR VGND VPWR VGND sky130_ef_sc_hd__decap_12
XFILLER_61_314 VGND VGND VPWR VPWR sky130_fd_sc_hd__decap_3
XFILLER_46_377 VPWR VGND VPWR VGND sky130_ef_sc_hd__decap_12
XTAP_TAPCELL_ROW_44_512 VGND VPWR sky130_fd_sc_hd__tapvpwrvgnd_1
XFILLER_14_241 VGND VGND VPWR VPWR sky130_fd_sc_hd__fill_2
X_0820_ cycle_count\[3\] net212 cycle_count\[1\] cycle_count\[0\] VGND VGND VPWR VPWR
+ _0583_ sky130_fd_sc_hd__nand4_1
XFILLER_9_57 VPWR VGND VPWR VGND sky130_ef_sc_hd__decap_12
XFILLER_14_285 VGND VGND VPWR VPWR sky130_fd_sc_hd__fill_2
XFILLER_69_447 VGND VGND VPWR VPWR sky130_fd_sc_hd__fill_1
X_1303_ net244 net165 scratch\[7\]\[29\] VGND VGND VPWR VPWR _0330_ sky130_fd_sc_hd__or3b_1
X_1165_ net405 net122 _0805_ VGND VGND VPWR VPWR _0090_ sky130_fd_sc_hd__a21o_1
X_1096_ net50 net185 net128 net353 VGND VGND VPWR VPWR _0039_ sky130_fd_sc_hd__a22o_1
XFILLER_37_322 VGND VGND VPWR VPWR sky130_fd_sc_hd__fill_1
X_1234_ net243 net175 scratch\[6\]\[27\] VGND VGND VPWR VPWR _0295_ sky130_fd_sc_hd__or3b_1
XTAP_TAPCELL_ROW_15_280 VGND VPWR sky130_fd_sc_hd__tapvpwrvgnd_1
XFILLER_20_233 VGND VGND VPWR VPWR sky130_fd_sc_hd__decap_8
XFILLER_20_266 VGND VGND VPWR VPWR sky130_fd_sc_hd__fill_1
X_0949_ scratch\[0\]\[18\] net227 _0692_ net259 net250 VGND VGND VPWR VPWR _0693_
+ sky130_fd_sc_hd__a221o_1
XFILLER_75_417 VGND VGND VPWR VPWR sky130_fd_sc_hd__decap_3
XTAP_TAPCELL_ROW_58_626 VGND VPWR sky130_fd_sc_hd__tapvpwrvgnd_1
XFILLER_70_177 VPWR VGND VPWR VGND sky130_ef_sc_hd__decap_12
XFILLER_70_133 VGND VGND VPWR VPWR sky130_fd_sc_hd__decap_6
XTAP_TAPCELL_ROW_66_692 VGND VPWR sky130_fd_sc_hd__tapvpwrvgnd_1
XFILLER_43_358 VGND VGND VPWR VPWR sky130_fd_sc_hd__decap_8
XFILLER_43_314 VGND VGND VPWR VPWR sky130_fd_sc_hd__decap_3
XFILLER_51_391 VGND VGND VPWR VPWR sky130_fd_sc_hd__fill_1
XFILLER_50_53 VPWR VGND VPWR VGND sky130_ef_sc_hd__decap_12
XFILLER_7_237 VPWR VGND VPWR VGND sky130_ef_sc_hd__decap_12
XFILLER_11_233 VGND VGND VPWR VPWR sky130_fd_sc_hd__fill_1
XFILLER_46_141 VGND VGND VPWR VPWR sky130_fd_sc_hd__fill_1
XFILLER_19_333 VGND VGND VPWR VPWR sky130_fd_sc_hd__decap_3
XFILLER_61_111 VGND VGND VPWR VPWR sky130_fd_sc_hd__fill_1
X_1852_ clknet_leaf_15_clock _0194_ VGND VGND VPWR VPWR scratch\[0\]\[23\] sky130_fd_sc_hd__dfxtp_1
XTAP_TAPCELL_ROW_29_394 VGND VPWR sky130_fd_sc_hd__tapvpwrvgnd_1
X_1921_ clknet_leaf_23_clock _0263_ VGND VGND VPWR VPWR scratch\[1\]\[28\] sky130_fd_sc_hd__dfxtp_1
X_1783_ clknet_leaf_22_clock _0126_ VGND VGND VPWR VPWR scratch\[6\]\[29\] sky130_fd_sc_hd__dfxtp_1
XTAP_TAPCELL_ROW_12_261 VGND VPWR sky130_fd_sc_hd__tapvpwrvgnd_1
XFILLER_69_233 VGND VGND VPWR VPWR sky130_fd_sc_hd__decap_3
XFILLER_57_428 VGND VGND VPWR VPWR sky130_fd_sc_hd__decap_3
XTAP_TAPCELL_ROW_55_607 VGND VPWR sky130_fd_sc_hd__tapvpwrvgnd_1
X_1148_ net18 net195 net179 net50 VGND VGND VPWR VPWR _0797_ sky130_fd_sc_hd__a22o_1
X_1217_ net31 net175 _0286_ VGND VGND VPWR VPWR _0115_ sky130_fd_sc_hd__a21bo_1
X_1079_ net39 net192 net135 net369 VGND VGND VPWR VPWR _0026_ sky130_fd_sc_hd__a22o_1
XFILLER_33_391 VGND VGND VPWR VPWR sky130_fd_sc_hd__fill_1
XPHY_EDGE_ROW_33_Left_109 VGND VGND VPWR VPWR sky130_fd_sc_hd__decap_3
XPHY_EDGE_ROW_42_Left_118 VGND VGND VPWR VPWR sky130_fd_sc_hd__decap_3
Xhold98 scratch\[2\]\[11\] VGND VGND VPWR VPWR net374 sky130_fd_sc_hd__dlygate4sd3_1
Xhold76 scratch\[5\]\[11\] VGND VGND VPWR VPWR net352 sky130_fd_sc_hd__dlygate4sd3_1
Xhold87 scratch\[4\]\[5\] VGND VGND VPWR VPWR net363 sky130_fd_sc_hd__dlygate4sd3_1
Xhold43 scratch\[5\]\[16\] VGND VGND VPWR VPWR net319 sky130_fd_sc_hd__dlygate4sd3_1
Xhold10 scratch\[1\]\[30\] VGND VGND VPWR VPWR net286 sky130_fd_sc_hd__dlygate4sd3_1
XFILLER_29_87 VPWR VGND VPWR VGND sky130_ef_sc_hd__decap_12
XFILLER_29_54 VGND VGND VPWR VPWR sky130_fd_sc_hd__fill_2
Xhold65 scratch\[5\]\[27\] VGND VGND VPWR VPWR net341 sky130_fd_sc_hd__dlygate4sd3_1
XFILLER_28_141 VPWR VGND VPWR VGND sky130_ef_sc_hd__decap_12
Xhold21 scratch\[4\]\[2\] VGND VGND VPWR VPWR net297 sky130_fd_sc_hd__dlygate4sd3_1
XTAP_TAPCELL_ROW_18_309 VGND VPWR sky130_fd_sc_hd__tapvpwrvgnd_1
Xhold32 scratch\[5\]\[3\] VGND VGND VPWR VPWR net308 sky130_fd_sc_hd__dlygate4sd3_1
Xhold54 scratch\[5\]\[31\] VGND VGND VPWR VPWR net330 sky130_fd_sc_hd__dlygate4sd3_1
XPHY_EDGE_ROW_51_Left_127 VGND VGND VPWR VPWR sky130_fd_sc_hd__decap_3
XFILLER_45_97 VGND VGND VPWR VPWR sky130_fd_sc_hd__fill_2
XFILLER_43_177 VGND VGND VPWR VPWR sky130_fd_sc_hd__fill_2
XFILLER_43_111 VGND VGND VPWR VPWR sky130_fd_sc_hd__fill_1
XTAP_TAPCELL_ROW_26_375 VGND VPWR sky130_fd_sc_hd__tapvpwrvgnd_1
XFILLER_16_358 VGND VGND VPWR VPWR sky130_fd_sc_hd__decap_6
XANTENNA_7 net235 VGND VGND VPWR VPWR sky130_fd_sc_hd__diode_2
XPHY_EDGE_ROW_60_Left_136 VGND VGND VPWR VPWR sky130_fd_sc_hd__decap_3
XFILLER_39_417 VGND VGND VPWR VPWR sky130_fd_sc_hd__fill_2
XFILLER_3_273 VGND VGND VPWR VPWR sky130_fd_sc_hd__decap_6
X_1002_ scratch\[4\]\[26\] net227 net218 scratch\[5\]\[26\] net234 VGND VGND VPWR
+ VPWR _0738_ sky130_fd_sc_hd__a221o_1
X_1904_ clknet_leaf_10_clock _0246_ VGND VGND VPWR VPWR scratch\[1\]\[11\] sky130_fd_sc_hd__dfxtp_1
XTAP_TAPCELL_ROW_60_643 VGND VPWR sky130_fd_sc_hd__tapvpwrvgnd_1
X_1835_ clknet_leaf_3_clock _0177_ VGND VGND VPWR VPWR scratch\[0\]\[6\] sky130_fd_sc_hd__dfxtp_1
XFILLER_34_177 VPWR VGND VPWR VGND sky130_ef_sc_hd__decap_12
XFILLER_15_391 VGND VGND VPWR VPWR sky130_fd_sc_hd__fill_1
X_1766_ clknet_leaf_11_clock _0109_ VGND VGND VPWR VPWR scratch\[6\]\[12\] sky130_fd_sc_hd__dfxtp_1
X_1697_ clknet_leaf_5_clock _0040_ VGND VGND VPWR VPWR scratch\[5\]\[7\] sky130_fd_sc_hd__dfxtp_1
XTAP_TAPCELL_ROW_68_710 VGND VPWR sky130_fd_sc_hd__tapvpwrvgnd_1
XFILLER_57_214 VGND VGND VPWR VPWR sky130_fd_sc_hd__decap_8
XFILLER_40_147 VGND VGND VPWR VPWR sky130_fd_sc_hd__fill_1
XFILLER_40_114 VGND VGND VPWR VPWR sky130_fd_sc_hd__decap_3
XFILLER_25_144 VGND VGND VPWR VPWR sky130_fd_sc_hd__decap_6
XTAP_TAPCELL_ROW_23_345 VGND VPWR sky130_fd_sc_hd__tapvpwrvgnd_1
XFILLER_15_45 VGND VGND VPWR VPWR sky130_fd_sc_hd__decap_8
Xoutput77 net77 VGND VGND VPWR VPWR host_output_data[11] sky130_fd_sc_hd__buf_2
Xoutput88 net88 VGND VGND VPWR VPWR host_output_data[21] sky130_fd_sc_hd__buf_2
XFILLER_48_214 VGND VGND VPWR VPWR sky130_fd_sc_hd__fill_1
Xoutput99 net99 VGND VGND VPWR VPWR host_output_data[31] sky130_fd_sc_hd__buf_2
XFILLER_0_221 VGND VGND VPWR VPWR sky130_fd_sc_hd__decap_3
XFILLER_0_276 VGND VGND VPWR VPWR sky130_fd_sc_hd__decap_4
XTAP_TAPCELL_ROW_74_757 VGND VPWR sky130_fd_sc_hd__tapvpwrvgnd_1
XFILLER_56_85 VGND VGND VPWR VPWR sky130_fd_sc_hd__decap_6
XFILLER_56_63 VGND VGND VPWR VPWR sky130_fd_sc_hd__fill_1
XFILLER_36_409 VGND VGND VPWR VPWR sky130_fd_sc_hd__decap_8
XFILLER_71_261 VPWR VGND VPWR VGND sky130_ef_sc_hd__decap_12
XFILLER_31_169 VGND VGND VPWR VPWR sky130_fd_sc_hd__fill_2
XFILLER_31_103 VGND VGND VPWR VPWR sky130_fd_sc_hd__decap_8
XFILLER_8_321 VPWR VGND VPWR VGND sky130_ef_sc_hd__decap_12
XFILLER_16_188 VGND VGND VPWR VPWR sky130_fd_sc_hd__decap_8
X_1551_ net23 _0490_ net138 VGND VGND VPWR VPWR _0491_ sky130_fd_sc_hd__mux2_1
X_1482_ net31 net144 net114 net406 VGND VGND VPWR VPWR _0221_ sky130_fd_sc_hd__a22o_1
X_1620_ net199 _0544_ _0545_ VGND VGND VPWR VPWR _0546_ sky130_fd_sc_hd__and3_1
XFILLER_8_365 VPWR VGND VPWR VGND sky130_ef_sc_hd__decap_12
XTAP_TAPCELL_ROW_37_459 VGND VPWR sky130_fd_sc_hd__tapvpwrvgnd_1
XFILLER_22_103 VGND VGND VPWR VPWR sky130_fd_sc_hd__decap_6
XFILLER_22_125 VPWR VGND VPWR VGND sky130_ef_sc_hd__decap_12
XFILLER_10_309 VGND VGND VPWR VPWR sky130_fd_sc_hd__decap_4
X_1818_ clknet_leaf_28_clock net194 VGND VGND VPWR VPWR net74 sky130_fd_sc_hd__dfxtp_1
XTAP_TAPCELL_ROW_20_326 VGND VPWR sky130_fd_sc_hd__tapvpwrvgnd_1
X_1749_ clknet_leaf_16_clock _0092_ VGND VGND VPWR VPWR scratch\[2\]\[16\] sky130_fd_sc_hd__dfxtp_1
XFILLER_9_129 VPWR VGND VPWR VGND sky130_ef_sc_hd__decap_12
XFILLER_13_136 VGND VGND VPWR VPWR sky130_fd_sc_hd__decap_6
XFILLER_13_169 VGND VGND VPWR VPWR sky130_fd_sc_hd__decap_8
XFILLER_5_335 VGND VGND VPWR VPWR sky130_fd_sc_hd__fill_1
XFILLER_67_51 VGND VGND VPWR VPWR sky130_fd_sc_hd__decap_4
XFILLER_36_217 VGND VGND VPWR VPWR sky130_fd_sc_hd__decap_3
XFILLER_3_15 VPWR VGND VPWR VGND sky130_ef_sc_hd__decap_12
XFILLER_44_272 VPWR VGND VPWR VGND sky130_ef_sc_hd__decap_12
XFILLER_32_445 VGND VGND VPWR VPWR sky130_fd_sc_hd__decap_8
XFILLER_66_3 VPWR VGND VPWR VGND sky130_ef_sc_hd__decap_12
X_0982_ net208 _0718_ _0721_ VGND VGND VPWR VPWR net89 sky130_fd_sc_hd__and3_1
XFILLER_8_195 VGND VGND VPWR VPWR sky130_fd_sc_hd__fill_1
X_1534_ scratch\[3\]\[7\] scratch\[2\]\[7\] VGND VGND VPWR VPWR _0477_ sky130_fd_sc_hd__or2_1
X_1603_ scratch\[3\]\[21\] scratch\[2\]\[21\] VGND VGND VPWR VPWR _0532_ sky130_fd_sc_hd__nand2_1
Xfanout119 net120 VGND VGND VPWR VPWR net119 sky130_fd_sc_hd__clkbuf_2
Xfanout108 net111 VGND VGND VPWR VPWR net108 sky130_fd_sc_hd__clkbuf_4
X_1465_ net33 net142 net112 net395 VGND VGND VPWR VPWR _0204_ sky130_fd_sc_hd__a22o_1
XFILLER_67_386 VGND VGND VPWR VPWR sky130_fd_sc_hd__decap_6
XFILLER_67_353 VGND VGND VPWR VPWR sky130_fd_sc_hd__fill_1
X_1396_ scratch\[0\]\[12\] _0381_ _0392_ VGND VGND VPWR VPWR _0395_ sky130_fd_sc_hd__and3_1
XFILLER_50_253 VGND VGND VPWR VPWR sky130_fd_sc_hd__fill_2
XFILLER_10_139 VGND VGND VPWR VPWR sky130_fd_sc_hd__fill_1
Xhold151 scratch\[3\]\[11\] VGND VGND VPWR VPWR net427 sky130_fd_sc_hd__dlygate4sd3_1
Xhold162 cycle_count\[0\] VGND VGND VPWR VPWR net438 sky130_fd_sc_hd__dlygate4sd3_1
Xclkbuf_leaf_17_clock clknet_2_2__leaf_clock VGND VGND VPWR VPWR clknet_leaf_17_clock
+ sky130_fd_sc_hd__clkbuf_8
Xhold140 scratch\[3\]\[3\] VGND VGND VPWR VPWR net416 sky130_fd_sc_hd__dlygate4sd3_1
XFILLER_12_35 VGND VGND VPWR VPWR sky130_fd_sc_hd__fill_1
XFILLER_37_54 VGND VGND VPWR VPWR sky130_fd_sc_hd__fill_2
XFILLER_14_401 VPWR VGND VPWR VGND sky130_ef_sc_hd__decap_12
XFILLER_68_139 VGND VGND VPWR VPWR sky130_fd_sc_hd__fill_1
XFILLER_64_334 VGND VGND VPWR VPWR sky130_fd_sc_hd__decap_8
XTAP_TAPCELL_ROW_47_543 VGND VPWR sky130_fd_sc_hd__tapvpwrvgnd_1
XFILLER_1_393 VPWR VGND VPWR VGND sky130_ef_sc_hd__decap_12
X_1181_ net22 net170 _0268_ VGND VGND VPWR VPWR _0097_ sky130_fd_sc_hd__a21bo_1
X_1250_ net44 net159 _0303_ VGND VGND VPWR VPWR _0131_ sky130_fd_sc_hd__a21bo_1
XFILLER_64_389 VPWR VGND VPWR VGND sky130_ef_sc_hd__decap_12
XFILLER_32_286 VPWR VGND VPWR VGND sky130_ef_sc_hd__decap_12
XFILLER_32_253 VPWR VGND VPWR VGND sky130_ef_sc_hd__decap_12
XFILLER_20_448 VGND VGND VPWR VPWR sky130_fd_sc_hd__fill_1
X_0896_ scratch\[1\]\[9\] net215 _0648_ net256 net248 VGND VGND VPWR VPWR _0649_ sky130_fd_sc_hd__a221o_1
X_0965_ scratch\[6\]\[20\] scratch\[7\]\[20\] net272 VGND VGND VPWR VPWR _0707_ sky130_fd_sc_hd__mux2_1
XFILLER_74_109 VPWR VGND VPWR VGND sky130_ef_sc_hd__decap_12
X_1517_ net312 net108 _0463_ VGND VGND VPWR VPWR _0238_ sky130_fd_sc_hd__a21o_1
X_1448_ net41 net157 net118 _0434_ VGND VGND VPWR VPWR _0198_ sky130_fd_sc_hd__a22o_1
XFILLER_67_161 VGND VGND VPWR VPWR sky130_fd_sc_hd__decap_6
XFILLER_55_334 VGND VGND VPWR VPWR sky130_fd_sc_hd__fill_2
X_1379_ net152 net204 _0381_ VGND VGND VPWR VPWR _0382_ sky130_fd_sc_hd__and3_1
XTAP_TAPCELL_ROW_2_179 VGND VPWR sky130_fd_sc_hd__tapvpwrvgnd_1
XFILLER_23_45 VGND VGND VPWR VPWR sky130_fd_sc_hd__decap_3
XFILLER_0_27 VGND VGND VPWR VPWR sky130_fd_sc_hd__fill_1
XFILLER_64_85 VPWR VGND VPWR VGND sky130_ef_sc_hd__decap_12
XFILLER_64_41 VPWR VGND VPWR VGND sky130_ef_sc_hd__decap_12
XFILLER_61_337 VPWR VGND VPWR VGND sky130_ef_sc_hd__decap_12
XFILLER_46_389 VPWR VGND VPWR VGND sky130_ef_sc_hd__decap_12
XTAP_TAPCELL_ROW_44_513 VGND VPWR sky130_fd_sc_hd__tapvpwrvgnd_1
XFILLER_9_69 VPWR VGND VPWR VGND sky130_ef_sc_hd__decap_12
XFILLER_14_253 VGND VGND VPWR VPWR sky130_fd_sc_hd__decap_6
X_1302_ net42 net165 _0329_ VGND VGND VPWR VPWR _0157_ sky130_fd_sc_hd__a21bo_1
X_1233_ net40 net175 _0294_ VGND VGND VPWR VPWR _0123_ sky130_fd_sc_hd__a21bo_1
X_1164_ net6 net197 net180 net27 VGND VGND VPWR VPWR _0805_ sky130_fd_sc_hd__a22o_1
X_1095_ net49 net185 net128 net347 VGND VGND VPWR VPWR _0038_ sky130_fd_sc_hd__a22o_1
X_0948_ scratch\[2\]\[18\] scratch\[3\]\[18\] net269 VGND VGND VPWR VPWR _0692_ sky130_fd_sc_hd__mux2_1
XTAP_TAPCELL_ROW_15_281 VGND VPWR sky130_fd_sc_hd__tapvpwrvgnd_1
X_0879_ net255 _0633_ _0634_ VGND VGND VPWR VPWR _0635_ sky130_fd_sc_hd__a21o_1
XTAP_TAPCELL_ROW_7_216 VGND VPWR sky130_fd_sc_hd__tapvpwrvgnd_1
XTAP_TAPCELL_ROW_58_627 VGND VPWR sky130_fd_sc_hd__tapvpwrvgnd_1
XFILLER_55_142 VGND VGND VPWR VPWR sky130_fd_sc_hd__decap_3
XFILLER_47_109 VGND VGND VPWR VPWR sky130_fd_sc_hd__decap_3
XFILLER_70_189 VGND VGND VPWR VPWR sky130_fd_sc_hd__decap_6
XTAP_TAPCELL_ROW_66_693 VGND VPWR sky130_fd_sc_hd__tapvpwrvgnd_1
XFILLER_43_337 VPWR VGND VPWR VGND sky130_ef_sc_hd__decap_12
XFILLER_34_88 VPWR VGND VPWR VGND sky130_ef_sc_hd__decap_12
XFILLER_28_378 VGND VGND VPWR VPWR sky130_fd_sc_hd__fill_1
XFILLER_50_65 VGND VGND VPWR VPWR sky130_fd_sc_hd__decap_3
XFILLER_7_205 VPWR VGND VPWR VGND sky130_ef_sc_hd__decap_12
XFILLER_7_249 VPWR VGND VPWR VGND sky130_ef_sc_hd__decap_12
XFILLER_59_52 VGND VGND VPWR VPWR sky130_fd_sc_hd__decap_4
XFILLER_46_197 VPWR VGND VPWR VGND sky130_ef_sc_hd__decap_12
XFILLER_34_337 VPWR VGND VPWR VGND sky130_ef_sc_hd__decap_12
XTAP_TAPCELL_ROW_29_395 VGND VPWR sky130_fd_sc_hd__tapvpwrvgnd_1
X_1851_ clknet_leaf_15_clock _0193_ VGND VGND VPWR VPWR scratch\[0\]\[22\] sky130_fd_sc_hd__dfxtp_1
X_1920_ clknet_leaf_17_clock _0262_ VGND VGND VPWR VPWR scratch\[1\]\[27\] sky130_fd_sc_hd__dfxtp_1
XTAP_TAPCELL_ROW_12_262 VGND VPWR sky130_fd_sc_hd__tapvpwrvgnd_1
X_1782_ clknet_leaf_22_clock _0125_ VGND VGND VPWR VPWR scratch\[6\]\[28\] sky130_fd_sc_hd__dfxtp_1
XFILLER_69_223 VGND VGND VPWR VPWR sky130_fd_sc_hd__fill_1
X_1216_ net243 net175 scratch\[6\]\[18\] VGND VGND VPWR VPWR _0286_ sky130_fd_sc_hd__or3b_1
XFILLER_52_167 VGND VGND VPWR VPWR sky130_fd_sc_hd__fill_2
X_1147_ net396 net121 _0796_ VGND VGND VPWR VPWR _0081_ sky130_fd_sc_hd__a21o_1
XFILLER_40_307 VGND VGND VPWR VPWR sky130_fd_sc_hd__fill_1
XFILLER_37_153 VGND VGND VPWR VPWR sky130_fd_sc_hd__decap_3
XFILLER_25_337 VPWR VGND VPWR VGND sky130_ef_sc_hd__decap_12
XFILLER_1_81 VPWR VGND VPWR VGND sky130_ef_sc_hd__decap_12
X_1078_ net38 net192 net135 net358 VGND VGND VPWR VPWR _0025_ sky130_fd_sc_hd__a22o_1
XFILLER_20_13 VPWR VGND VPWR VGND sky130_ef_sc_hd__decap_12
Xhold11 scratch\[1\]\[20\] VGND VGND VPWR VPWR net287 sky130_fd_sc_hd__dlygate4sd3_1
Xhold22 scratch\[1\]\[8\] VGND VGND VPWR VPWR net298 sky130_fd_sc_hd__dlygate4sd3_1
XFILLER_20_46 VGND VGND VPWR VPWR sky130_fd_sc_hd__fill_1
XFILLER_75_248 VGND VGND VPWR VPWR sky130_fd_sc_hd__decap_4
Xhold66 scratch\[4\]\[12\] VGND VGND VPWR VPWR net342 sky130_fd_sc_hd__dlygate4sd3_1
XFILLER_48_429 VGND VGND VPWR VPWR sky130_fd_sc_hd__decap_3
Xhold77 scratch\[5\]\[6\] VGND VGND VPWR VPWR net353 sky130_fd_sc_hd__dlygate4sd3_1
XFILLER_45_21 VGND VGND VPWR VPWR sky130_fd_sc_hd__decap_8
Xhold88 scratch\[5\]\[4\] VGND VGND VPWR VPWR net364 sky130_fd_sc_hd__dlygate4sd3_1
XFILLER_29_99 VPWR VGND VPWR VGND sky130_ef_sc_hd__decap_12
Xhold99 scratch\[2\]\[2\] VGND VGND VPWR VPWR net375 sky130_fd_sc_hd__dlygate4sd3_1
XFILLER_28_197 VPWR VGND VPWR VGND sky130_ef_sc_hd__decap_12
XFILLER_28_153 VGND VGND VPWR VPWR sky130_fd_sc_hd__decap_8
Xhold33 scratch\[1\]\[2\] VGND VGND VPWR VPWR net309 sky130_fd_sc_hd__dlygate4sd3_1
Xhold44 scratch\[5\]\[0\] VGND VGND VPWR VPWR net320 sky130_fd_sc_hd__dlygate4sd3_1
Xhold55 scratch\[5\]\[29\] VGND VGND VPWR VPWR net331 sky130_fd_sc_hd__dlygate4sd3_1
XFILLER_6_26 VGND VGND VPWR VPWR sky130_fd_sc_hd__fill_2
XFILLER_13_6 VPWR VGND VPWR VGND sky130_ef_sc_hd__decap_12
XFILLER_62_421 VPWR VGND VPWR VGND sky130_ef_sc_hd__decap_12
XFILLER_34_189 VGND VGND VPWR VPWR sky130_fd_sc_hd__decap_6
XFILLER_34_112 VPWR VGND VPWR VGND sky130_ef_sc_hd__decap_12
X_1001_ scratch\[6\]\[26\] scratch\[7\]\[26\] net269 VGND VGND VPWR VPWR _0737_ sky130_fd_sc_hd__mux2_1
X_1765_ clknet_leaf_11_clock _0108_ VGND VGND VPWR VPWR scratch\[6\]\[11\] sky130_fd_sc_hd__dfxtp_1
XTAP_TAPCELL_ROW_60_644 VGND VPWR sky130_fd_sc_hd__tapvpwrvgnd_1
X_1834_ clknet_leaf_3_clock _0176_ VGND VGND VPWR VPWR scratch\[0\]\[5\] sky130_fd_sc_hd__dfxtp_1
X_1903_ clknet_leaf_2_clock _0245_ VGND VGND VPWR VPWR scratch\[1\]\[10\] sky130_fd_sc_hd__dfxtp_1
X_1696_ clknet_leaf_3_clock _0039_ VGND VGND VPWR VPWR scratch\[5\]\[6\] sky130_fd_sc_hd__dfxtp_1
XTAP_TAPCELL_ROW_68_711 VGND VPWR sky130_fd_sc_hd__tapvpwrvgnd_1
XFILLER_65_281 VPWR VGND VPWR VGND sky130_ef_sc_hd__decap_12
XFILLER_38_451 VGND VGND VPWR VPWR sky130_fd_sc_hd__fill_2
XFILLER_25_156 VPWR VGND VPWR VGND sky130_ef_sc_hd__decap_12
XTAP_TAPCELL_ROW_23_346 VGND VPWR sky130_fd_sc_hd__tapvpwrvgnd_1
XFILLER_31_34 VPWR VGND VPWR VGND sky130_ef_sc_hd__decap_12
Xoutput78 net78 VGND VGND VPWR VPWR host_output_data[12] sky130_fd_sc_hd__buf_2
Xoutput89 net89 VGND VGND VPWR VPWR host_output_data[22] sky130_fd_sc_hd__buf_2
XFILLER_29_440 VGND VGND VPWR VPWR sky130_fd_sc_hd__fill_1
XTAP_TAPCELL_ROW_74_758 VGND VPWR sky130_fd_sc_hd__tapvpwrvgnd_1
XFILLER_72_41 VPWR VGND VPWR VGND sky130_ef_sc_hd__decap_12
XFILLER_71_273 VGND VGND VPWR VPWR sky130_fd_sc_hd__decap_6
XFILLER_44_421 VGND VGND VPWR VPWR sky130_fd_sc_hd__decap_4
XFILLER_16_167 VGND VGND VPWR VPWR sky130_fd_sc_hd__decap_4
XFILLER_72_85 VPWR VGND VPWR VGND sky130_ef_sc_hd__decap_12
XFILLER_31_126 VGND VGND VPWR VPWR sky130_fd_sc_hd__fill_2
XFILLER_8_333 VPWR VGND VPWR VGND sky130_ef_sc_hd__decap_12
XFILLER_8_377 VPWR VGND VPWR VGND sky130_ef_sc_hd__decap_12
XFILLER_12_362 VGND VGND VPWR VPWR sky130_fd_sc_hd__fill_2
X_1481_ net30 net145 net115 net402 VGND VGND VPWR VPWR _0220_ sky130_fd_sc_hd__a22o_1
X_1550_ net196 _0488_ _0489_ VGND VGND VPWR VPWR _0490_ sky130_fd_sc_hd__and3_1
XFILLER_22_137 VGND VGND VPWR VPWR sky130_fd_sc_hd__decap_3
X_1748_ clknet_leaf_16_clock _0091_ VGND VGND VPWR VPWR scratch\[2\]\[15\] sky130_fd_sc_hd__dfxtp_1
X_1817_ clknet_leaf_26_clock _0160_ VGND VGND VPWR VPWR scratch\[7\]\[31\] sky130_fd_sc_hd__dfxtp_1
XTAP_TAPCELL_ROW_20_327 VGND VPWR sky130_fd_sc_hd__tapvpwrvgnd_1
X_1679_ clknet_leaf_13_clock _0022_ VGND VGND VPWR VPWR scratch\[4\]\[21\] sky130_fd_sc_hd__dfxtp_1
XTAP_TAPCELL_ROW_71_728 VGND VPWR sky130_fd_sc_hd__tapvpwrvgnd_1
XFILLER_26_421 VGND VGND VPWR VPWR sky130_fd_sc_hd__fill_1
XFILLER_3_27 VPWR VGND VPWR VGND sky130_ef_sc_hd__decap_12
XFILLER_17_421 VGND VGND VPWR VPWR sky130_fd_sc_hd__decap_4
XFILLER_44_284 VGND VGND VPWR VPWR sky130_fd_sc_hd__decap_8
XFILLER_44_251 VGND VGND VPWR VPWR sky130_fd_sc_hd__fill_1
X_0981_ net260 _0719_ _0720_ VGND VGND VPWR VPWR _0721_ sky130_fd_sc_hd__a21o_1
XFILLER_59_3 VPWR VGND VPWR VGND sky130_ef_sc_hd__decap_12
X_1602_ net287 net110 _0531_ VGND VGND VPWR VPWR _0255_ sky130_fd_sc_hd__a21o_1
XTAP_TAPCELL_ROW_42_496 VGND VPWR sky130_fd_sc_hd__tapvpwrvgnd_1
XFILLER_8_141 VPWR VGND VPWR VGND sky130_ef_sc_hd__decap_12
X_1533_ scratch\[3\]\[7\] scratch\[2\]\[7\] VGND VGND VPWR VPWR _0476_ sky130_fd_sc_hd__nand2_1
X_1395_ net152 _0393_ VGND VGND VPWR VPWR _0394_ sky130_fd_sc_hd__nand2_1
Xfanout109 net110 VGND VGND VPWR VPWR net109 sky130_fd_sc_hd__clkbuf_4
X_1464_ net22 net142 net112 net403 VGND VGND VPWR VPWR _0203_ sky130_fd_sc_hd__a22o_1
Xclkbuf_0_clock clock VGND VGND VPWR VPWR clknet_0_clock sky130_fd_sc_hd__clkbuf_16
XTAP_TAPCELL_ROW_33_430 VGND VPWR sky130_fd_sc_hd__tapvpwrvgnd_1
Xhold152 scratch\[3\]\[4\] VGND VGND VPWR VPWR net428 sky130_fd_sc_hd__dlygate4sd3_1
Xhold130 scratch\[3\]\[18\] VGND VGND VPWR VPWR net406 sky130_fd_sc_hd__dlygate4sd3_1
Xhold163 scratch\[0\]\[31\] VGND VGND VPWR VPWR net439 sky130_fd_sc_hd__dlygate4sd3_1
Xhold141 scratch\[3\]\[29\] VGND VGND VPWR VPWR net417 sky130_fd_sc_hd__dlygate4sd3_1
XFILLER_73_335 VGND VGND VPWR VPWR sky130_fd_sc_hd__fill_1
XFILLER_58_365 VPWR VGND VPWR VGND sky130_ef_sc_hd__decap_12
XFILLER_41_243 VPWR VGND VPWR VGND sky130_ef_sc_hd__decap_12
XFILLER_41_221 VGND VGND VPWR VPWR sky130_fd_sc_hd__decap_3
XFILLER_14_413 VGND VGND VPWR VPWR sky130_fd_sc_hd__decap_6
XFILLER_5_111 VGND VGND VPWR VPWR sky130_fd_sc_hd__fill_1
XFILLER_49_310 VPWR VGND VPWR VGND sky130_ef_sc_hd__decap_12
XFILLER_45_9 VPWR VGND VPWR VGND sky130_ef_sc_hd__decap_12
XFILLER_1_361 VPWR VGND VPWR VGND sky130_ef_sc_hd__decap_12
XFILLER_64_324 VGND VGND VPWR VPWR sky130_fd_sc_hd__decap_3
X_1180_ net237 net170 scratch\[6\]\[0\] VGND VGND VPWR VPWR _0268_ sky130_fd_sc_hd__or3b_1
X_0964_ scratch\[1\]\[20\] net220 _0705_ VGND VGND VPWR VPWR _0706_ sky130_fd_sc_hd__a21o_1
XFILLER_32_298 VGND VGND VPWR VPWR sky130_fd_sc_hd__decap_8
XFILLER_32_265 VGND VGND VPWR VPWR sky130_fd_sc_hd__decap_4
XTAP_TAPCELL_ROW_30_400 VGND VPWR sky130_fd_sc_hd__tapvpwrvgnd_1
X_0895_ scratch\[2\]\[9\] scratch\[3\]\[9\] net266 VGND VGND VPWR VPWR _0648_ sky130_fd_sc_hd__mux2_1
X_1516_ net47 _0462_ net137 VGND VGND VPWR VPWR _0463_ sky130_fd_sc_hd__mux2_1
X_1378_ scratch\[0\]\[8\] scratch\[0\]\[9\] scratch\[0\]\[10\] scratch\[0\]\[11\]
+ VGND VGND VPWR VPWR _0381_ sky130_fd_sc_hd__and4_1
X_1447_ net153 _0433_ _0430_ scratch\[0\]\[27\] VGND VGND VPWR VPWR _0434_ sky130_fd_sc_hd__o2bb2a_1
XFILLER_63_390 VGND VGND VPWR VPWR sky130_fd_sc_hd__fill_2
XFILLER_11_405 VPWR VGND VPWR VGND sky130_ef_sc_hd__decap_12
XFILLER_48_21 VGND VGND VPWR VPWR sky130_fd_sc_hd__decap_6
XFILLER_64_53 VPWR VGND VPWR VGND sky130_ef_sc_hd__decap_12
XFILLER_58_173 VGND VGND VPWR VPWR sky130_fd_sc_hd__decap_3
XFILLER_48_76 VGND VGND VPWR VPWR sky130_fd_sc_hd__decap_8
XFILLER_48_65 VGND VGND VPWR VPWR sky130_fd_sc_hd__decap_4
XTAP_TAPCELL_ROW_44_514 VGND VPWR sky130_fd_sc_hd__tapvpwrvgnd_1
XFILLER_64_97 VPWR VGND VPWR VGND sky130_ef_sc_hd__decap_12
XFILLER_61_349 VGND VGND VPWR VPWR sky130_fd_sc_hd__fill_1
XTAP_TAPCELL_ROW_52_580 VGND VPWR sky130_fd_sc_hd__tapvpwrvgnd_1
XFILLER_14_265 VPWR VGND VPWR VGND sky130_ef_sc_hd__decap_12
XFILLER_69_449 VGND VGND VPWR VPWR sky130_fd_sc_hd__decap_4
XFILLER_69_405 VPWR VGND VPWR VGND sky130_ef_sc_hd__decap_12
XFILLER_49_151 VGND VGND VPWR VPWR sky130_fd_sc_hd__decap_4
X_1301_ net244 net165 scratch\[7\]\[28\] VGND VGND VPWR VPWR _0329_ sky130_fd_sc_hd__or3b_1
X_1232_ net243 net175 scratch\[6\]\[26\] VGND VGND VPWR VPWR _0294_ sky130_fd_sc_hd__or3b_1
X_1163_ net376 net123 _0804_ VGND VGND VPWR VPWR _0089_ sky130_fd_sc_hd__a21o_1
Xclkbuf_leaf_16_clock clknet_2_3__leaf_clock VGND VGND VPWR VPWR clknet_leaf_16_clock
+ sky130_fd_sc_hd__clkbuf_8
XFILLER_37_335 VGND VGND VPWR VPWR sky130_fd_sc_hd__fill_1
X_1094_ net48 net185 net127 net364 VGND VGND VPWR VPWR _0037_ sky130_fd_sc_hd__a22o_1
XFILLER_60_360 VGND VGND VPWR VPWR sky130_fd_sc_hd__decap_4
X_0947_ net251 _0688_ _0691_ net209 VGND VGND VPWR VPWR net83 sky130_fd_sc_hd__o211a_1
XTAP_TAPCELL_ROW_15_282 VGND VPWR sky130_fd_sc_hd__tapvpwrvgnd_1
X_0878_ scratch\[4\]\[6\] net223 net214 scratch\[5\]\[6\] net232 VGND VGND VPWR VPWR
+ _0634_ sky130_fd_sc_hd__a221o_1
XTAP_TAPCELL_ROW_7_217 VGND VPWR sky130_fd_sc_hd__tapvpwrvgnd_1
XTAP_TAPCELL_ROW_58_628 VGND VPWR sky130_fd_sc_hd__tapvpwrvgnd_1
XTAP_TAPCELL_ROW_66_694 VGND VPWR sky130_fd_sc_hd__tapvpwrvgnd_1
XFILLER_43_349 VGND VGND VPWR VPWR sky130_fd_sc_hd__fill_2
XFILLER_34_34 VGND VGND VPWR VPWR sky130_fd_sc_hd__fill_1
XFILLER_11_213 VGND VGND VPWR VPWR sky130_fd_sc_hd__decap_8
XFILLER_11_257 VGND VGND VPWR VPWR sky130_fd_sc_hd__decap_8
Xclkload0 clknet_2_1__leaf_clock VGND VGND VPWR VPWR clkload0/X sky130_fd_sc_hd__clkbuf_8
XFILLER_7_217 VGND VGND VPWR VPWR sky130_fd_sc_hd__decap_6
XFILLER_11_279 VGND VGND VPWR VPWR sky130_fd_sc_hd__fill_1
XFILLER_66_408 VPWR VGND VPWR VGND sky130_ef_sc_hd__decap_12
Xfanout270 net273 VGND VGND VPWR VPWR net270 sky130_fd_sc_hd__clkbuf_2
XFILLER_75_85 VPWR VGND VPWR VGND sky130_ef_sc_hd__decap_12
XFILLER_75_41 VPWR VGND VPWR VGND sky130_ef_sc_hd__decap_12
XFILLER_61_124 VPWR VGND VPWR VGND sky130_ef_sc_hd__decap_12
XFILLER_61_113 VGND VGND VPWR VPWR sky130_fd_sc_hd__fill_2
XFILLER_46_110 VGND VGND VPWR VPWR sky130_fd_sc_hd__decap_6
XFILLER_34_349 VGND VGND VPWR VPWR sky130_fd_sc_hd__decap_6
XTAP_TAPCELL_ROW_29_396 VGND VPWR sky130_fd_sc_hd__tapvpwrvgnd_1
X_1850_ clknet_leaf_15_clock _0192_ VGND VGND VPWR VPWR scratch\[0\]\[21\] sky130_fd_sc_hd__dfxtp_1
X_1781_ clknet_leaf_18_clock _0124_ VGND VGND VPWR VPWR scratch\[6\]\[27\] sky130_fd_sc_hd__dfxtp_1
XTAP_TAPCELL_ROW_12_263 VGND VPWR sky130_fd_sc_hd__tapvpwrvgnd_1
XFILLER_69_279 VGND VGND VPWR VPWR sky130_fd_sc_hd__fill_1
X_1215_ net30 net177 _0285_ VGND VGND VPWR VPWR _0114_ sky130_fd_sc_hd__a21bo_1
XFILLER_65_441 VGND VGND VPWR VPWR sky130_fd_sc_hd__decap_6
X_1146_ net17 net196 net180 net49 VGND VGND VPWR VPWR _0796_ sky130_fd_sc_hd__a22o_1
XFILLER_37_110 VGND VGND VPWR VPWR sky130_fd_sc_hd__fill_2
XTAP_TAPCELL_ROW_63_664 VGND VPWR sky130_fd_sc_hd__tapvpwrvgnd_1
XFILLER_52_102 VPWR VGND VPWR VGND sky130_ef_sc_hd__decap_12
X_1077_ net37 net191 net134 net337 VGND VGND VPWR VPWR _0024_ sky130_fd_sc_hd__a22o_1
XFILLER_33_393 VPWR VGND VPWR VGND sky130_ef_sc_hd__decap_12
XFILLER_25_349 VGND VGND VPWR VPWR sky130_fd_sc_hd__decap_8
XFILLER_25_327 VGND VGND VPWR VPWR sky130_fd_sc_hd__decap_8
XFILLER_1_93 VPWR VGND VPWR VGND sky130_ef_sc_hd__decap_12
XFILLER_4_209 VPWR VGND VPWR VGND sky130_ef_sc_hd__decap_12
XFILLER_20_25 VGND VGND VPWR VPWR sky130_fd_sc_hd__decap_3
Xhold45 scratch\[4\]\[19\] VGND VGND VPWR VPWR net321 sky130_fd_sc_hd__dlygate4sd3_1
Xhold23 scratch\[1\]\[5\] VGND VGND VPWR VPWR net299 sky130_fd_sc_hd__dlygate4sd3_1
Xhold12 scratch\[1\]\[16\] VGND VGND VPWR VPWR net288 sky130_fd_sc_hd__dlygate4sd3_1
Xhold34 scratch\[1\]\[4\] VGND VGND VPWR VPWR net310 sky130_fd_sc_hd__dlygate4sd3_1
Xhold56 scratch\[4\]\[31\] VGND VGND VPWR VPWR net332 sky130_fd_sc_hd__dlygate4sd3_1
Xhold89 scratch\[4\]\[7\] VGND VGND VPWR VPWR net365 sky130_fd_sc_hd__dlygate4sd3_1
XFILLER_43_157 VGND VGND VPWR VPWR sky130_fd_sc_hd__fill_1
XFILLER_43_113 VGND VGND VPWR VPWR sky130_fd_sc_hd__decap_8
Xhold67 scratch\[5\]\[26\] VGND VGND VPWR VPWR net343 sky130_fd_sc_hd__dlygate4sd3_1
Xhold78 scratch\[5\]\[30\] VGND VGND VPWR VPWR net354 sky130_fd_sc_hd__dlygate4sd3_1
XFILLER_61_65 VGND VGND VPWR VPWR sky130_fd_sc_hd__decap_3
XFILLER_61_54 VGND VGND VPWR VPWR sky130_fd_sc_hd__fill_2
X_1000_ scratch\[0\]\[26\] scratch\[2\]\[26\] scratch\[1\]\[26\] scratch\[3\]\[26\]
+ net259 net269 VGND VGND VPWR VPWR _0736_ sky130_fd_sc_hd__mux4_1
XFILLER_62_433 VPWR VGND VPWR VGND sky130_ef_sc_hd__decap_12
XTAP_TAPCELL_ROW_60_645 VGND VPWR sky130_fd_sc_hd__tapvpwrvgnd_1
X_1902_ clknet_leaf_8_clock _0244_ VGND VGND VPWR VPWR scratch\[1\]\[9\] sky130_fd_sc_hd__dfxtp_1
XFILLER_34_124 VGND VGND VPWR VPWR sky130_fd_sc_hd__fill_2
XFILLER_15_393 VPWR VGND VPWR VGND sky130_ef_sc_hd__decap_12
XTAP_TAPCELL_ROW_17_300 VGND VPWR sky130_fd_sc_hd__tapvpwrvgnd_1
XFILLER_19_198 VGND VGND VPWR VPWR sky130_fd_sc_hd__fill_2
X_1764_ clknet_leaf_6_clock _0107_ VGND VGND VPWR VPWR scratch\[6\]\[10\] sky130_fd_sc_hd__dfxtp_1
X_1833_ clknet_leaf_2_clock _0175_ VGND VGND VPWR VPWR scratch\[0\]\[4\] sky130_fd_sc_hd__dfxtp_1
XFILLER_30_363 VGND VGND VPWR VPWR sky130_fd_sc_hd__fill_1
X_1695_ clknet_leaf_3_clock _0038_ VGND VGND VPWR VPWR scratch\[5\]\[5\] sky130_fd_sc_hd__dfxtp_1
XFILLER_65_293 VGND VGND VPWR VPWR sky130_fd_sc_hd__decap_8
XFILLER_57_249 VPWR VGND VPWR VGND sky130_ef_sc_hd__decap_12
XFILLER_25_113 VPWR VGND VPWR VGND sky130_ef_sc_hd__decap_12
X_1129_ net39 net181 net123 net412 VGND VGND VPWR VPWR _0069_ sky130_fd_sc_hd__a22o_1
XFILLER_31_24 VGND VGND VPWR VPWR sky130_fd_sc_hd__decap_6
XTAP_TAPCELL_ROW_23_347 VGND VPWR sky130_fd_sc_hd__tapvpwrvgnd_1
XFILLER_21_352 VPWR VGND VPWR VGND sky130_ef_sc_hd__decap_12
XFILLER_31_79 VGND VGND VPWR VPWR sky130_fd_sc_hd__decap_4
XFILLER_31_57 VPWR VGND VPWR VGND sky130_ef_sc_hd__decap_12
XFILLER_31_46 VGND VGND VPWR VPWR sky130_fd_sc_hd__decap_8
XFILLER_56_43 VGND VGND VPWR VPWR sky130_fd_sc_hd__fill_2
Xoutput79 net79 VGND VGND VPWR VPWR host_output_data[13] sky130_fd_sc_hd__clkbuf_4
XFILLER_0_234 VGND VGND VPWR VPWR sky130_fd_sc_hd__decap_3
Xoutput68 net211 VGND VGND VPWR VPWR busy sky130_fd_sc_hd__clkbuf_4
XTAP_TAPCELL_ROW_74_759 VGND VPWR sky130_fd_sc_hd__tapvpwrvgnd_1
XFILLER_72_53 VPWR VGND VPWR VGND sky130_ef_sc_hd__decap_12
XFILLER_12_330 VPWR VGND VPWR VGND sky130_ef_sc_hd__decap_12
XFILLER_16_113 VGND VGND VPWR VPWR sky130_fd_sc_hd__decap_4
XPHY_EDGE_ROW_19_Right_19 VGND VGND VPWR VPWR sky130_fd_sc_hd__decap_3
XFILLER_72_97 VPWR VGND VPWR VGND sky130_ef_sc_hd__decap_12
XFILLER_8_345 VPWR VGND VPWR VGND sky130_ef_sc_hd__decap_12
XFILLER_8_389 VPWR VGND VPWR VGND sky130_ef_sc_hd__decap_12
X_1480_ net29 net144 net114 net422 VGND VGND VPWR VPWR _0219_ sky130_fd_sc_hd__a22o_1
XPHY_EDGE_ROW_28_Right_28 VGND VGND VPWR VPWR sky130_fd_sc_hd__decap_3
XPHY_EDGE_ROW_37_Right_37 VGND VGND VPWR VPWR sky130_fd_sc_hd__decap_3
XFILLER_22_149 VGND VGND VPWR VPWR sky130_fd_sc_hd__fill_2
X_1747_ clknet_leaf_7_clock _0090_ VGND VGND VPWR VPWR scratch\[2\]\[14\] sky130_fd_sc_hd__dfxtp_1
X_1678_ clknet_leaf_13_clock _0021_ VGND VGND VPWR VPWR scratch\[4\]\[20\] sky130_fd_sc_hd__dfxtp_1
XPHY_EDGE_ROW_46_Right_46 VGND VGND VPWR VPWR sky130_fd_sc_hd__decap_3
XFILLER_7_81 VPWR VGND VPWR VGND sky130_ef_sc_hd__decap_12
X_1816_ clknet_leaf_26_clock _0159_ VGND VGND VPWR VPWR scratch\[7\]\[30\] sky130_fd_sc_hd__dfxtp_1
XPHY_EDGE_ROW_55_Right_55 VGND VGND VPWR VPWR sky130_fd_sc_hd__decap_3
XTAP_TAPCELL_ROW_71_729 VGND VPWR sky130_fd_sc_hd__tapvpwrvgnd_1
XFILLER_53_296 VGND VGND VPWR VPWR sky130_fd_sc_hd__decap_3
XFILLER_53_263 VGND VGND VPWR VPWR sky130_fd_sc_hd__decap_4
XTAP_TAPCELL_ROW_36_450 VGND VPWR sky130_fd_sc_hd__tapvpwrvgnd_1
XFILLER_26_13 VPWR VGND VPWR VGND sky130_ef_sc_hd__decap_12
XFILLER_13_105 VGND VGND VPWR VPWR sky130_fd_sc_hd__decap_6
XPHY_EDGE_ROW_64_Right_64 VGND VGND VPWR VPWR sky130_fd_sc_hd__decap_3
XPHY_EDGE_ROW_39_Left_115 VGND VGND VPWR VPWR sky130_fd_sc_hd__decap_3
XFILLER_5_337 VPWR VGND VPWR VGND sky130_ef_sc_hd__decap_12
XFILLER_9_109 VGND VGND VPWR VPWR sky130_fd_sc_hd__decap_3
XFILLER_3_39 VPWR VGND VPWR VGND sky130_ef_sc_hd__decap_12
XPHY_EDGE_ROW_73_Right_73 VGND VGND VPWR VPWR sky130_fd_sc_hd__decap_3
XPHY_EDGE_ROW_48_Left_124 VGND VGND VPWR VPWR sky130_fd_sc_hd__decap_3
XFILLER_29_271 VGND VGND VPWR VPWR sky130_fd_sc_hd__fill_1
XTAP_TAPCELL_ROW_42_497 VGND VPWR sky130_fd_sc_hd__tapvpwrvgnd_1
X_0980_ scratch\[4\]\[22\] net229 net219 scratch\[5\]\[22\] net233 VGND VGND VPWR
+ VPWR _0720_ sky130_fd_sc_hd__a221o_1
X_1601_ net34 _0530_ net140 VGND VGND VPWR VPWR _0531_ sky130_fd_sc_hd__mux2_1
XPHY_EDGE_ROW_57_Left_133 VGND VGND VPWR VPWR sky130_fd_sc_hd__decap_3
X_1532_ net295 net107 _0475_ VGND VGND VPWR VPWR _0241_ sky130_fd_sc_hd__a21o_1
XFILLER_8_153 VPWR VGND VPWR VGND sky130_ef_sc_hd__decap_12
XFILLER_8_197 VPWR VGND VPWR VGND sky130_ef_sc_hd__decap_12
XPHY_EDGE_ROW_66_Left_142 VGND VGND VPWR VPWR sky130_fd_sc_hd__decap_3
X_1394_ _0384_ _0392_ VGND VGND VPWR VPWR _0393_ sky130_fd_sc_hd__and2_1
X_1463_ net238 net142 VGND VGND VPWR VPWR _0445_ sky130_fd_sc_hd__nor2_1
XPHY_EDGE_ROW_75_Left_151 VGND VGND VPWR VPWR sky130_fd_sc_hd__decap_3
XTAP_TAPCELL_ROW_33_431 VGND VPWR sky130_fd_sc_hd__tapvpwrvgnd_1
XFILLER_12_26 VGND VGND VPWR VPWR sky130_fd_sc_hd__fill_2
XFILLER_12_59 VGND VGND VPWR VPWR sky130_fd_sc_hd__decap_4
Xhold153 scratch\[3\]\[20\] VGND VGND VPWR VPWR net429 sky130_fd_sc_hd__dlygate4sd3_1
Xhold120 scratch\[2\]\[5\] VGND VGND VPWR VPWR net396 sky130_fd_sc_hd__dlygate4sd3_1
Xhold164 cycle_count\[2\] VGND VGND VPWR VPWR net440 sky130_fd_sc_hd__dlygate4sd3_1
Xhold131 scratch\[2\]\[27\] VGND VGND VPWR VPWR net407 sky130_fd_sc_hd__dlygate4sd3_1
Xhold142 scratch\[2\]\[29\] VGND VGND VPWR VPWR net418 sky130_fd_sc_hd__dlygate4sd3_1
XFILLER_2_307 VGND VGND VPWR VPWR sky130_fd_sc_hd__fill_1
XFILLER_58_377 VGND VGND VPWR VPWR sky130_fd_sc_hd__decap_3
XFILLER_53_55 VGND VGND VPWR VPWR sky130_fd_sc_hd__fill_1
XFILLER_41_255 VGND VGND VPWR VPWR sky130_fd_sc_hd__fill_2
XFILLER_5_167 VGND VGND VPWR VPWR sky130_fd_sc_hd__fill_1
XFILLER_49_322 VGND VGND VPWR VPWR sky130_fd_sc_hd__fill_2
XFILLER_1_373 VPWR VGND VPWR VGND sky130_ef_sc_hd__decap_12
XFILLER_49_388 VGND VGND VPWR VPWR sky130_fd_sc_hd__decap_4
XFILLER_71_3 VPWR VGND VPWR VGND sky130_ef_sc_hd__decap_12
X_0894_ net207 _0644_ _0647_ VGND VGND VPWR VPWR net105 sky130_fd_sc_hd__and3_1
X_0963_ scratch\[0\]\[20\] net228 _0704_ net260 net251 VGND VGND VPWR VPWR _0705_
+ sky130_fd_sc_hd__a221o_1
XFILLER_32_277 VGND VGND VPWR VPWR sky130_fd_sc_hd__fill_1
XTAP_TAPCELL_ROW_30_401 VGND VPWR sky130_fd_sc_hd__tapvpwrvgnd_1
XFILLER_59_119 VGND VGND VPWR VPWR sky130_fd_sc_hd__fill_1
X_1515_ net197 _0460_ _0461_ VGND VGND VPWR VPWR _0462_ sky130_fd_sc_hd__and3_1
X_1377_ net152 _0378_ scratch\[0\]\[11\] VGND VGND VPWR VPWR _0380_ sky130_fd_sc_hd__a21oi_1
X_1446_ _0371_ _0395_ _0419_ _0432_ VGND VGND VPWR VPWR _0433_ sky130_fd_sc_hd__and4_1
XFILLER_23_277 VGND VGND VPWR VPWR sky130_fd_sc_hd__decap_3
XFILLER_11_417 VPWR VGND VPWR VGND sky130_ef_sc_hd__decap_12
XFILLER_58_141 VPWR VGND VPWR VGND sky130_ef_sc_hd__decap_12
XFILLER_73_111 VGND VGND VPWR VPWR sky130_fd_sc_hd__fill_1
XFILLER_64_65 VPWR VGND VPWR VGND sky130_ef_sc_hd__decap_12
XFILLER_46_358 VGND VGND VPWR VPWR sky130_fd_sc_hd__decap_6
XTAP_TAPCELL_ROW_44_515 VGND VPWR sky130_fd_sc_hd__tapvpwrvgnd_1
XFILLER_0_29 VPWR VGND VPWR VGND sky130_ef_sc_hd__decap_12
XTAP_TAPCELL_ROW_1_170 VGND VPWR sky130_fd_sc_hd__tapvpwrvgnd_1
XTAP_TAPCELL_ROW_52_581 VGND VPWR sky130_fd_sc_hd__tapvpwrvgnd_1
XFILLER_14_277 VGND VGND VPWR VPWR sky130_fd_sc_hd__decap_8
XFILLER_69_417 VPWR VGND VPWR VGND sky130_ef_sc_hd__decap_12
XFILLER_43_7 VGND VGND VPWR VPWR sky130_fd_sc_hd__fill_1
XFILLER_6_421 VPWR VGND VPWR VGND sky130_ef_sc_hd__decap_12
XFILLER_49_163 VGND VGND VPWR VPWR sky130_fd_sc_hd__decap_4
X_1162_ net5 net198 net181 net26 VGND VGND VPWR VPWR _0804_ sky130_fd_sc_hd__a22o_1
XFILLER_36_6 VGND VGND VPWR VPWR sky130_fd_sc_hd__decap_4
X_1300_ net41 net168 _0328_ VGND VGND VPWR VPWR _0156_ sky130_fd_sc_hd__a21bo_1
XFILLER_1_181 VPWR VGND VPWR VGND sky130_ef_sc_hd__decap_12
X_1231_ net39 net175 _0293_ VGND VGND VPWR VPWR _0122_ sky130_fd_sc_hd__a21bo_1
XFILLER_64_188 VGND VGND VPWR VPWR sky130_fd_sc_hd__fill_1
XFILLER_52_339 VGND VGND VPWR VPWR sky130_fd_sc_hd__decap_8
X_1093_ net47 net184 net127 net308 VGND VGND VPWR VPWR _0036_ sky130_fd_sc_hd__a22o_1
X_0946_ net261 _0689_ _0690_ VGND VGND VPWR VPWR _0691_ sky130_fd_sc_hd__a21o_1
X_0877_ scratch\[6\]\[6\] scratch\[7\]\[6\] net265 VGND VGND VPWR VPWR _0633_ sky130_fd_sc_hd__mux2_1
XFILLER_9_281 VGND VGND VPWR VPWR sky130_fd_sc_hd__decap_8
XTAP_TAPCELL_ROW_15_283 VGND VPWR sky130_fd_sc_hd__tapvpwrvgnd_1
X_1429_ net151 _0393_ _0419_ VGND VGND VPWR VPWR _0420_ sky130_fd_sc_hd__nand3_1
XTAP_TAPCELL_ROW_7_218 VGND VPWR sky130_fd_sc_hd__tapvpwrvgnd_1
XTAP_TAPCELL_ROW_66_695 VGND VPWR sky130_fd_sc_hd__tapvpwrvgnd_1
XTAP_TAPCELL_ROW_58_629 VGND VPWR sky130_fd_sc_hd__tapvpwrvgnd_1
XFILLER_51_350 VPWR VGND VPWR VGND sky130_ef_sc_hd__decap_12
Xclkload1 clknet_2_2__leaf_clock VGND VGND VPWR VPWR clkload1/X sky130_fd_sc_hd__clkbuf_8
XFILLER_11_225 VGND VGND VPWR VPWR sky130_fd_sc_hd__decap_8
XFILLER_59_43 VGND VGND VPWR VPWR sky130_fd_sc_hd__fill_1
XFILLER_1_3 VPWR VGND VPWR VGND sky130_ef_sc_hd__decap_12
XFILLER_75_53 VGND VGND VPWR VPWR sky130_fd_sc_hd__decap_3
Xfanout271 net273 VGND VGND VPWR VPWR net271 sky130_fd_sc_hd__clkbuf_4
Xfanout260 net262 VGND VGND VPWR VPWR net260 sky130_fd_sc_hd__buf_2
XFILLER_75_97 VPWR VGND VPWR VGND sky130_ef_sc_hd__decap_12
XFILLER_61_136 VPWR VGND VPWR VGND sky130_ef_sc_hd__decap_12
XFILLER_34_306 VGND VGND VPWR VPWR sky130_fd_sc_hd__fill_2
XTAP_TAPCELL_ROW_29_397 VGND VPWR sky130_fd_sc_hd__tapvpwrvgnd_1
XFILLER_6_251 VGND VGND VPWR VPWR sky130_fd_sc_hd__fill_1
X_1780_ clknet_leaf_19_clock _0123_ VGND VGND VPWR VPWR scratch\[6\]\[26\] sky130_fd_sc_hd__dfxtp_1
XFILLER_69_225 VGND VGND VPWR VPWR sky130_fd_sc_hd__decap_8
XFILLER_34_3 VGND VGND VPWR VPWR sky130_fd_sc_hd__decap_3
X_1214_ net245 net177 scratch\[6\]\[17\] VGND VGND VPWR VPWR _0285_ sky130_fd_sc_hd__or3b_1
XFILLER_52_114 VGND VGND VPWR VPWR sky130_fd_sc_hd__decap_6
XFILLER_37_166 VGND VGND VPWR VPWR sky130_fd_sc_hd__fill_2
X_1145_ net383 net121 _0795_ VGND VGND VPWR VPWR _0080_ sky130_fd_sc_hd__a21o_1
XTAP_TAPCELL_ROW_63_665 VGND VPWR sky130_fd_sc_hd__tapvpwrvgnd_1
X_1076_ net36 net191 net134 net348 VGND VGND VPWR VPWR _0023_ sky130_fd_sc_hd__a22o_1
XFILLER_40_309 VGND VGND VPWR VPWR sky130_fd_sc_hd__decap_4
X_0929_ net257 _0675_ _0676_ VGND VGND VPWR VPWR _0677_ sky130_fd_sc_hd__a21o_1
XFILLER_75_228 VPWR VGND VPWR VGND sky130_ef_sc_hd__decap_12
XFILLER_75_206 VGND VGND VPWR VPWR sky130_fd_sc_hd__decap_3
Xhold35 scratch\[5\]\[12\] VGND VGND VPWR VPWR net311 sky130_fd_sc_hd__dlygate4sd3_1
Xhold57 scratch\[4\]\[16\] VGND VGND VPWR VPWR net333 sky130_fd_sc_hd__dlygate4sd3_1
Xhold46 scratch\[5\]\[22\] VGND VGND VPWR VPWR net322 sky130_fd_sc_hd__dlygate4sd3_1
XFILLER_28_111 VGND VGND VPWR VPWR sky130_fd_sc_hd__decap_3
Xhold24 scratch\[1\]\[29\] VGND VGND VPWR VPWR net300 sky130_fd_sc_hd__dlygate4sd3_1
XFILLER_0_449 VGND VGND VPWR VPWR sky130_fd_sc_hd__decap_4
XFILLER_0_405 VPWR VGND VPWR VGND sky130_ef_sc_hd__decap_12
Xhold79 scratch\[4\]\[1\] VGND VGND VPWR VPWR net355 sky130_fd_sc_hd__dlygate4sd3_1
Xhold13 scratch\[1\]\[0\] VGND VGND VPWR VPWR net289 sky130_fd_sc_hd__dlygate4sd3_1
Xhold68 scratch\[5\]\[25\] VGND VGND VPWR VPWR net344 sky130_fd_sc_hd__dlygate4sd3_1
XFILLER_43_147 VGND VGND VPWR VPWR sky130_fd_sc_hd__fill_2
XFILLER_43_103 VGND VGND VPWR VPWR sky130_fd_sc_hd__decap_8
XFILLER_16_306 VGND VGND VPWR VPWR sky130_fd_sc_hd__fill_2
Xclkbuf_leaf_15_clock clknet_2_3__leaf_clock VGND VGND VPWR VPWR clknet_leaf_15_clock
+ sky130_fd_sc_hd__clkbuf_8
XTAP_TAPCELL_ROW_17_301 VGND VPWR sky130_fd_sc_hd__tapvpwrvgnd_1
XFILLER_19_111 VGND VGND VPWR VPWR sky130_fd_sc_hd__fill_1
XFILLER_62_445 VGND VGND VPWR VPWR sky130_fd_sc_hd__decap_8
XTAP_TAPCELL_ROW_60_646 VGND VPWR sky130_fd_sc_hd__tapvpwrvgnd_1
X_1901_ clknet_leaf_6_clock _0243_ VGND VGND VPWR VPWR scratch\[1\]\[8\] sky130_fd_sc_hd__dfxtp_1
X_1832_ clknet_leaf_1_clock _0174_ VGND VGND VPWR VPWR scratch\[0\]\[3\] sky130_fd_sc_hd__dfxtp_1
XFILLER_15_361 VPWR VGND VPWR VGND sky130_ef_sc_hd__decap_12
X_1763_ clknet_leaf_7_clock _0106_ VGND VGND VPWR VPWR scratch\[6\]\[9\] sky130_fd_sc_hd__dfxtp_1
X_1694_ clknet_leaf_1_clock _0037_ VGND VGND VPWR VPWR scratch\[5\]\[4\] sky130_fd_sc_hd__dfxtp_1
XFILLER_72_209 VPWR VGND VPWR VGND sky130_ef_sc_hd__decap_12
X_1059_ net49 net189 net132 net363 VGND VGND VPWR VPWR _0006_ sky130_fd_sc_hd__a22o_1
X_1128_ net38 net182 net124 net413 VGND VGND VPWR VPWR _0068_ sky130_fd_sc_hd__a22o_1
XFILLER_25_169 VGND VGND VPWR VPWR sky130_fd_sc_hd__decap_8
XFILLER_25_125 VGND VGND VPWR VPWR sky130_fd_sc_hd__decap_3
XPHY_EDGE_ROW_11_Left_87 VGND VGND VPWR VPWR sky130_fd_sc_hd__decap_3
XFILLER_15_15 VPWR VGND VPWR VGND sky130_ef_sc_hd__decap_12
XTAP_TAPCELL_ROW_23_348 VGND VPWR sky130_fd_sc_hd__tapvpwrvgnd_1
XFILLER_21_331 VGND VGND VPWR VPWR sky130_fd_sc_hd__decap_4
XFILLER_21_364 VGND VGND VPWR VPWR sky130_fd_sc_hd__decap_6
XFILLER_31_69 VGND VGND VPWR VPWR sky130_fd_sc_hd__fill_2
XFILLER_0_213 VGND VGND VPWR VPWR sky130_fd_sc_hd__decap_8
Xoutput69 net69 VGND VGND VPWR VPWR current_stage[0] sky130_fd_sc_hd__clkbuf_4
XFILLER_56_11 VGND VGND VPWR VPWR sky130_fd_sc_hd__fill_1
XFILLER_0_257 VGND VGND VPWR VPWR sky130_fd_sc_hd__fill_1
XFILLER_72_65 VPWR VGND VPWR VGND sky130_ef_sc_hd__decap_12
XFILLER_31_117 VGND VGND VPWR VPWR sky130_fd_sc_hd__fill_1
XFILLER_12_342 VPWR VGND VPWR VGND sky130_ef_sc_hd__decap_12
XFILLER_8_357 VGND VGND VPWR VPWR sky130_fd_sc_hd__decap_6
XFILLER_62_253 VPWR VGND VPWR VGND sky130_ef_sc_hd__decap_12
XFILLER_47_250 VGND VGND VPWR VPWR sky130_fd_sc_hd__decap_4
XFILLER_30_172 VGND VGND VPWR VPWR sky130_fd_sc_hd__fill_1
X_1815_ clknet_leaf_22_clock _0158_ VGND VGND VPWR VPWR scratch\[7\]\[29\] sky130_fd_sc_hd__dfxtp_1
X_1677_ clknet_leaf_10_clock _0020_ VGND VGND VPWR VPWR scratch\[4\]\[19\] sky130_fd_sc_hd__dfxtp_1
X_1746_ clknet_leaf_16_clock _0089_ VGND VGND VPWR VPWR scratch\[2\]\[13\] sky130_fd_sc_hd__dfxtp_1
XFILLER_7_93 VPWR VGND VPWR VGND sky130_ef_sc_hd__decap_12
XFILLER_38_250 VGND VGND VPWR VPWR sky130_fd_sc_hd__fill_2
XFILLER_53_275 VGND VGND VPWR VPWR sky130_fd_sc_hd__decap_4
XTAP_TAPCELL_ROW_36_451 VGND VPWR sky130_fd_sc_hd__tapvpwrvgnd_1
XFILLER_26_445 VGND VGND VPWR VPWR sky130_fd_sc_hd__decap_8
XFILLER_26_25 VGND VGND VPWR VPWR sky130_fd_sc_hd__decap_3
XFILLER_5_349 VPWR VGND VPWR VGND sky130_ef_sc_hd__decap_12
XFILLER_5_305 VPWR VGND VPWR VGND sky130_ef_sc_hd__decap_12
XFILLER_44_253 VGND VGND VPWR VPWR sky130_fd_sc_hd__decap_8
XTAP_TAPCELL_ROW_42_498 VGND VPWR sky130_fd_sc_hd__tapvpwrvgnd_1
X_1600_ net201 _0528_ _0529_ VGND VGND VPWR VPWR _0530_ sky130_fd_sc_hd__and3_1
X_1531_ net50 _0474_ net138 VGND VGND VPWR VPWR _0475_ sky130_fd_sc_hd__mux2_1
X_1462_ net274 _0784_ net276 VGND VGND VPWR VPWR _0444_ sky130_fd_sc_hd__nor3b_1
XFILLER_8_165 VPWR VGND VPWR VGND sky130_ef_sc_hd__decap_12
X_1393_ scratch\[0\]\[13\] scratch\[0\]\[14\] scratch\[0\]\[15\] VGND VGND VPWR VPWR
+ _0392_ sky130_fd_sc_hd__and3_1
XFILLER_27_209 VPWR VGND VPWR VGND sky130_ef_sc_hd__decap_12
XFILLER_50_234 VPWR VGND VPWR VGND sky130_ef_sc_hd__decap_12
Xhold110 scratch\[2\]\[19\] VGND VGND VPWR VPWR net386 sky130_fd_sc_hd__dlygate4sd3_1
Xhold154 scratch\[3\]\[9\] VGND VGND VPWR VPWR net430 sky130_fd_sc_hd__dlygate4sd3_1
Xhold132 scratch\[2\]\[7\] VGND VGND VPWR VPWR net408 sky130_fd_sc_hd__dlygate4sd3_1
Xhold143 scratch\[2\]\[30\] VGND VGND VPWR VPWR net419 sky130_fd_sc_hd__dlygate4sd3_1
X_1729_ clknet_leaf_24_clock _0072_ VGND VGND VPWR VPWR scratch\[2\]\[28\] sky130_fd_sc_hd__dfxtp_1
Xhold121 scratch\[2\]\[31\] VGND VGND VPWR VPWR net397 sky130_fd_sc_hd__dlygate4sd3_1
Xhold165 scratch\[0\]\[2\] VGND VGND VPWR VPWR net441 sky130_fd_sc_hd__dlygate4sd3_1
XFILLER_73_337 VPWR VGND VPWR VGND sky130_ef_sc_hd__decap_12
XFILLER_37_57 VGND VGND VPWR VPWR sky130_fd_sc_hd__decap_8
XFILLER_26_253 VPWR VGND VPWR VGND sky130_ef_sc_hd__decap_12
XFILLER_53_89 VGND VGND VPWR VPWR sky130_fd_sc_hd__decap_6
XPHY_EDGE_ROW_14_Left_90 VGND VGND VPWR VPWR sky130_fd_sc_hd__decap_3
XFILLER_5_113 VPWR VGND VPWR VGND sky130_ef_sc_hd__decap_12
XFILLER_68_109 VPWR VGND VPWR VGND sky130_ef_sc_hd__decap_12
XFILLER_1_385 VGND VGND VPWR VPWR sky130_fd_sc_hd__decap_6
XFILLER_17_275 VGND VGND VPWR VPWR sky130_fd_sc_hd__decap_4
XFILLER_64_3 VPWR VGND VPWR VGND sky130_ef_sc_hd__decap_12
X_0893_ net256 _0645_ _0646_ VGND VGND VPWR VPWR _0647_ sky130_fd_sc_hd__a21o_1
X_0962_ scratch\[2\]\[20\] scratch\[3\]\[20\] net272 VGND VGND VPWR VPWR _0704_ sky130_fd_sc_hd__mux2_1
XTAP_TAPCELL_ROW_30_402 VGND VPWR sky130_fd_sc_hd__tapvpwrvgnd_1
XFILLER_9_441 VGND VGND VPWR VPWR sky130_fd_sc_hd__decap_6
X_1445_ scratch\[0\]\[27\] _0428_ VGND VGND VPWR VPWR _0432_ sky130_fd_sc_hd__and2_1
X_1514_ scratch\[3\]\[3\] scratch\[2\]\[3\] VGND VGND VPWR VPWR _0461_ sky130_fd_sc_hd__or2_1
XFILLER_4_83 VGND VGND VPWR VPWR sky130_fd_sc_hd__fill_1
XFILLER_70_307 VGND VGND VPWR VPWR sky130_fd_sc_hd__fill_1
XFILLER_67_186 VPWR VGND VPWR VGND sky130_ef_sc_hd__decap_12
XFILLER_55_337 VPWR VGND VPWR VGND sky130_ef_sc_hd__decap_12
XFILLER_55_326 VGND VGND VPWR VPWR sky130_fd_sc_hd__decap_8
X_1376_ net23 net155 net117 _0379_ VGND VGND VPWR VPWR _0181_ sky130_fd_sc_hd__a22o_1
XFILLER_63_370 VPWR VGND VPWR VGND sky130_ef_sc_hd__decap_12
XFILLER_23_289 VGND VGND VPWR VPWR sky130_fd_sc_hd__fill_2
XFILLER_23_245 VPWR VGND VPWR VGND sky130_ef_sc_hd__decap_12
XFILLER_23_223 VGND VGND VPWR VPWR sky130_fd_sc_hd__fill_1
XFILLER_11_429 VPWR VGND VPWR VGND sky130_ef_sc_hd__decap_12
XFILLER_58_153 VPWR VGND VPWR VGND sky130_ef_sc_hd__decap_12
XFILLER_73_167 VGND VGND VPWR VPWR sky130_fd_sc_hd__fill_1
XFILLER_64_77 VGND VGND VPWR VPWR sky130_fd_sc_hd__decap_6
XFILLER_58_197 VGND VGND VPWR VPWR sky130_fd_sc_hd__fill_2
XTAP_TAPCELL_ROW_44_516 VGND VPWR sky130_fd_sc_hd__tapvpwrvgnd_1
XTAP_TAPCELL_ROW_1_171 VGND VPWR sky130_fd_sc_hd__tapvpwrvgnd_1
XTAP_TAPCELL_ROW_52_582 VGND VPWR sky130_fd_sc_hd__tapvpwrvgnd_1
XFILLER_6_433 VPWR VGND VPWR VGND sky130_ef_sc_hd__decap_12
XFILLER_13_81 VPWR VGND VPWR VGND sky130_ef_sc_hd__decap_12
XFILLER_69_429 VPWR VGND VPWR VGND sky130_ef_sc_hd__decap_12
XFILLER_50_9 VPWR VGND VPWR VGND sky130_ef_sc_hd__decap_12
XFILLER_64_167 VGND VGND VPWR VPWR sky130_fd_sc_hd__fill_1
X_1161_ net388 net125 _0803_ VGND VGND VPWR VPWR _0088_ sky130_fd_sc_hd__a21o_1
XFILLER_52_307 VGND VGND VPWR VPWR sky130_fd_sc_hd__fill_1
XFILLER_37_348 VGND VGND VPWR VPWR sky130_fd_sc_hd__decap_8
XFILLER_37_337 VGND VGND VPWR VPWR sky130_fd_sc_hd__decap_4
XFILLER_1_193 VPWR VGND VPWR VGND sky130_ef_sc_hd__decap_12
X_1230_ net243 net175 scratch\[6\]\[25\] VGND VGND VPWR VPWR _0293_ sky130_fd_sc_hd__or3b_1
X_1092_ net44 net184 net127 net291 VGND VGND VPWR VPWR _0035_ sky130_fd_sc_hd__a22o_1
XTAP_TAPCELL_ROW_15_284 VGND VPWR sky130_fd_sc_hd__tapvpwrvgnd_1
XFILLER_20_248 VGND VGND VPWR VPWR sky130_fd_sc_hd__decap_4
X_0945_ scratch\[4\]\[17\] net228 net219 scratch\[5\]\[17\] net233 VGND VGND VPWR
+ VPWR _0690_ sky130_fd_sc_hd__a221o_1
X_0876_ scratch\[0\]\[6\] net223 _0631_ VGND VGND VPWR VPWR _0632_ sky130_fd_sc_hd__a21o_1
X_1428_ scratch\[0\]\[22\] scratch\[0\]\[23\] _0400_ _0412_ VGND VGND VPWR VPWR _0419_
+ sky130_fd_sc_hd__and4_1
XFILLER_28_304 VGND VGND VPWR VPWR sky130_fd_sc_hd__decap_4
XTAP_TAPCELL_ROW_7_219 VGND VPWR sky130_fd_sc_hd__tapvpwrvgnd_1
XFILLER_55_134 VGND VGND VPWR VPWR sky130_fd_sc_hd__decap_8
X_1359_ net147 _0365_ scratch\[0\]\[6\] VGND VGND VPWR VPWR _0367_ sky130_fd_sc_hd__a21oi_1
XFILLER_18_48 VPWR VGND VPWR VGND sky130_ef_sc_hd__decap_12
XFILLER_51_362 VPWR VGND VPWR VGND sky130_ef_sc_hd__decap_12
Xclkload2 clknet_leaf_0_clock VGND VGND VPWR VPWR clkload2/Y sky130_fd_sc_hd__clkinvlp_4
XFILLER_11_204 VGND VGND VPWR VPWR sky130_fd_sc_hd__fill_1
XFILLER_3_447 VGND VGND VPWR VPWR sky130_fd_sc_hd__fill_1
XFILLER_74_421 VPWR VGND VPWR VGND sky130_ef_sc_hd__decap_12
Xfanout272 net273 VGND VGND VPWR VPWR net272 sky130_fd_sc_hd__clkbuf_4
Xfanout261 net262 VGND VGND VPWR VPWR net261 sky130_fd_sc_hd__buf_2
XFILLER_19_337 VGND VGND VPWR VPWR sky130_fd_sc_hd__decap_4
Xfanout250 net251 VGND VGND VPWR VPWR net250 sky130_fd_sc_hd__clkbuf_4
XFILLER_61_148 VPWR VGND VPWR VGND sky130_ef_sc_hd__decap_12
XTAP_TAPCELL_ROW_29_398 VGND VPWR sky130_fd_sc_hd__tapvpwrvgnd_1
XFILLER_24_91 VPWR VGND VPWR VGND sky130_ef_sc_hd__decap_12
XFILLER_69_259 VGND VGND VPWR VPWR sky130_fd_sc_hd__decap_4
X_1213_ net29 net177 _0284_ VGND VGND VPWR VPWR _0113_ sky130_fd_sc_hd__a21bo_1
XFILLER_52_137 VGND VGND VPWR VPWR sky130_fd_sc_hd__decap_3
X_1075_ net35 net193 net136 net338 VGND VGND VPWR VPWR _0022_ sky130_fd_sc_hd__a22o_1
XFILLER_37_134 VGND VGND VPWR VPWR sky130_fd_sc_hd__decap_8
X_1144_ net16 net194 net179 net48 VGND VGND VPWR VPWR _0795_ sky130_fd_sc_hd__a22o_1
XFILLER_1_51 VGND VGND VPWR VPWR sky130_fd_sc_hd__decap_4
XFILLER_18_381 VGND VGND VPWR VPWR sky130_fd_sc_hd__fill_2
XTAP_TAPCELL_ROW_63_666 VGND VPWR sky130_fd_sc_hd__tapvpwrvgnd_1
XFILLER_33_351 VPWR VGND VPWR VGND sky130_ef_sc_hd__decap_12
X_0928_ scratch\[4\]\[14\] net224 net215 scratch\[5\]\[14\] net232 VGND VGND VPWR
+ VPWR _0676_ sky130_fd_sc_hd__a221o_1
XFILLER_0_417 VGND VGND VPWR VPWR sky130_fd_sc_hd__decap_3
X_0859_ scratch\[4\]\[3\] net222 _0617_ net254 net231 VGND VGND VPWR VPWR _0618_ sky130_fd_sc_hd__a221o_1
Xhold14 scratch\[1\]\[12\] VGND VGND VPWR VPWR net290 sky130_fd_sc_hd__dlygate4sd3_1
XFILLER_56_421 VPWR VGND VPWR VGND sky130_ef_sc_hd__decap_12
Xhold69 scratch\[4\]\[8\] VGND VGND VPWR VPWR net345 sky130_fd_sc_hd__dlygate4sd3_1
Xhold47 scratch\[4\]\[11\] VGND VGND VPWR VPWR net323 sky130_fd_sc_hd__dlygate4sd3_1
Xhold58 scratch\[5\]\[23\] VGND VGND VPWR VPWR net334 sky130_fd_sc_hd__dlygate4sd3_1
Xhold36 scratch\[1\]\[3\] VGND VGND VPWR VPWR net312 sky130_fd_sc_hd__dlygate4sd3_1
Xhold25 scratch\[1\]\[31\] VGND VGND VPWR VPWR net301 sky130_fd_sc_hd__dlygate4sd3_1
XTAP_TAPCELL_ROW_26_368 VGND VPWR sky130_fd_sc_hd__tapvpwrvgnd_1
XFILLER_24_362 VGND VGND VPWR VPWR sky130_fd_sc_hd__fill_2
XFILLER_6_18 VGND VGND VPWR VPWR sky130_fd_sc_hd__decap_8
XFILLER_6_29 VPWR VGND VPWR VGND sky130_ef_sc_hd__decap_12
XFILLER_74_251 VGND VGND VPWR VPWR sky130_fd_sc_hd__fill_1
XFILLER_59_281 VGND VGND VPWR VPWR sky130_fd_sc_hd__fill_2
XTAP_TAPCELL_ROW_17_302 VGND VPWR sky130_fd_sc_hd__tapvpwrvgnd_1
XFILLER_19_91 VGND VGND VPWR VPWR sky130_fd_sc_hd__fill_1
XFILLER_19_167 VGND VGND VPWR VPWR sky130_fd_sc_hd__fill_1
XTAP_TAPCELL_ROW_60_647 VGND VPWR sky130_fd_sc_hd__tapvpwrvgnd_1
X_1900_ clknet_leaf_5_clock _0242_ VGND VGND VPWR VPWR scratch\[1\]\[7\] sky130_fd_sc_hd__dfxtp_1
XFILLER_30_365 VGND VGND VPWR VPWR sky130_fd_sc_hd__fill_1
XFILLER_30_321 VGND VGND VPWR VPWR sky130_fd_sc_hd__fill_2
X_1831_ clknet_leaf_29_clock _0173_ VGND VGND VPWR VPWR scratch\[0\]\[2\] sky130_fd_sc_hd__dfxtp_1
XFILLER_15_373 VPWR VGND VPWR VGND sky130_ef_sc_hd__decap_12
X_1762_ clknet_leaf_6_clock _0105_ VGND VGND VPWR VPWR scratch\[6\]\[8\] sky130_fd_sc_hd__dfxtp_1
X_1693_ clknet_leaf_27_clock _0036_ VGND VGND VPWR VPWR scratch\[5\]\[3\] sky130_fd_sc_hd__dfxtp_1
X_1127_ net37 net181 net125 net401 VGND VGND VPWR VPWR _0067_ sky130_fd_sc_hd__a22o_1
X_1058_ net48 net189 net132 net357 VGND VGND VPWR VPWR _0005_ sky130_fd_sc_hd__a22o_1
XFILLER_33_181 VPWR VGND VPWR VGND sky130_ef_sc_hd__decap_12
XFILLER_15_27 VGND VGND VPWR VPWR sky130_fd_sc_hd__decap_4
XTAP_TAPCELL_ROW_23_349 VGND VPWR sky130_fd_sc_hd__tapvpwrvgnd_1
XPHY_EDGE_ROW_1_Right_1 VGND VGND VPWR VPWR sky130_fd_sc_hd__decap_3
XFILLER_0_225 VGND VGND VPWR VPWR sky130_fd_sc_hd__decap_4
XFILLER_56_295 VGND VGND VPWR VPWR sky130_fd_sc_hd__fill_1
XFILLER_56_251 VGND VGND VPWR VPWR sky130_fd_sc_hd__fill_1
XFILLER_72_77 VGND VGND VPWR VPWR sky130_fd_sc_hd__decap_6
XFILLER_12_354 VGND VGND VPWR VPWR sky130_fd_sc_hd__decap_8
XFILLER_12_365 VPWR VGND VPWR VGND sky130_ef_sc_hd__decap_12
XFILLER_11_6 VPWR VGND VPWR VGND sky130_ef_sc_hd__decap_12
XTAP_TAPCELL_ROW_73_750 VGND VPWR sky130_fd_sc_hd__tapvpwrvgnd_1
XFILLER_62_265 VGND VGND VPWR VPWR sky130_fd_sc_hd__decap_4
XFILLER_62_221 VGND VGND VPWR VPWR sky130_fd_sc_hd__decap_8
XFILLER_35_446 VGND VGND VPWR VPWR sky130_fd_sc_hd__fill_2
XFILLER_35_424 VPWR VGND VPWR VGND sky130_ef_sc_hd__decap_12
X_1745_ clknet_leaf_7_clock _0088_ VGND VGND VPWR VPWR scratch\[2\]\[12\] sky130_fd_sc_hd__dfxtp_1
XFILLER_30_195 VGND VGND VPWR VPWR sky130_fd_sc_hd__fill_1
X_1814_ clknet_leaf_22_clock _0157_ VGND VGND VPWR VPWR scratch\[7\]\[28\] sky130_fd_sc_hd__dfxtp_1
X_1676_ clknet_leaf_18_clock _0019_ VGND VGND VPWR VPWR scratch\[4\]\[18\] sky130_fd_sc_hd__dfxtp_1
XFILLER_7_391 VGND VGND VPWR VPWR sky130_fd_sc_hd__fill_1
XFILLER_26_37 VGND VGND VPWR VPWR sky130_fd_sc_hd__fill_1
Xclkbuf_leaf_14_clock clknet_2_3__leaf_clock VGND VGND VPWR VPWR clknet_leaf_14_clock
+ sky130_fd_sc_hd__clkbuf_8
XTAP_TAPCELL_ROW_36_452 VGND VPWR sky130_fd_sc_hd__tapvpwrvgnd_1
Xclkbuf_leaf_29_clock clknet_2_0__leaf_clock VGND VGND VPWR VPWR clknet_leaf_29_clock
+ sky130_fd_sc_hd__clkbuf_8
XFILLER_21_151 VGND VGND VPWR VPWR sky130_fd_sc_hd__fill_1
XFILLER_5_317 VPWR VGND VPWR VGND sky130_ef_sc_hd__decap_12
XFILLER_67_55 VGND VGND VPWR VPWR sky130_fd_sc_hd__fill_1
XTAP_TAPCELL_ROW_70_720 VGND VPWR sky130_fd_sc_hd__tapvpwrvgnd_1
XFILLER_44_265 VGND VGND VPWR VPWR sky130_fd_sc_hd__decap_3
XFILLER_44_243 VGND VGND VPWR VPWR sky130_fd_sc_hd__decap_8
XFILLER_44_232 VGND VGND VPWR VPWR sky130_fd_sc_hd__fill_1
XFILLER_17_446 VGND VGND VPWR VPWR sky130_fd_sc_hd__fill_2
XTAP_TAPCELL_ROW_42_499 VGND VPWR sky130_fd_sc_hd__tapvpwrvgnd_1
XFILLER_8_100 VPWR VGND VPWR VGND sky130_ef_sc_hd__decap_12
XFILLER_8_177 VPWR VGND VPWR VGND sky130_ef_sc_hd__decap_12
XFILLER_12_195 VGND VGND VPWR VPWR sky130_fd_sc_hd__fill_1
X_1392_ net152 _0389_ scratch\[0\]\[15\] VGND VGND VPWR VPWR _0391_ sky130_fd_sc_hd__a21o_1
X_1530_ net195 _0472_ _0473_ VGND VGND VPWR VPWR _0474_ sky130_fd_sc_hd__and3_1
X_1461_ _0580_ net195 _0441_ _0443_ VGND VGND VPWR VPWR _0202_ sky130_fd_sc_hd__a31o_1
XFILLER_50_279 VGND VGND VPWR VPWR sky130_fd_sc_hd__fill_2
XFILLER_50_246 VGND VGND VPWR VPWR sky130_fd_sc_hd__decap_6
XFILLER_23_427 VGND VGND VPWR VPWR sky130_fd_sc_hd__decap_4
Xhold122 scratch\[3\]\[23\] VGND VGND VPWR VPWR net398 sky130_fd_sc_hd__dlygate4sd3_1
Xhold100 scratch\[2\]\[13\] VGND VGND VPWR VPWR net376 sky130_fd_sc_hd__dlygate4sd3_1
Xhold111 scratch\[2\]\[6\] VGND VGND VPWR VPWR net387 sky130_fd_sc_hd__dlygate4sd3_1
Xhold133 scratch\[3\]\[27\] VGND VGND VPWR VPWR net409 sky130_fd_sc_hd__dlygate4sd3_1
X_1728_ clknet_leaf_19_clock _0071_ VGND VGND VPWR VPWR scratch\[2\]\[27\] sky130_fd_sc_hd__dfxtp_1
Xhold144 scratch\[3\]\[26\] VGND VGND VPWR VPWR net420 sky130_fd_sc_hd__dlygate4sd3_1
XFILLER_2_309 VPWR VGND VPWR VGND sky130_ef_sc_hd__decap_12
Xhold155 scratch\[3\]\[22\] VGND VGND VPWR VPWR net431 sky130_fd_sc_hd__dlygate4sd3_1
Xhold166 cycle_count\[3\] VGND VGND VPWR VPWR net442 sky130_fd_sc_hd__dlygate4sd3_1
X_1659_ clknet_leaf_27_clock _0002_ VGND VGND VPWR VPWR scratch\[4\]\[1\] sky130_fd_sc_hd__dfxtp_1
XFILLER_73_349 VPWR VGND VPWR VGND sky130_ef_sc_hd__decap_12
XFILLER_73_305 VPWR VGND VPWR VGND sky130_ef_sc_hd__decap_12
XFILLER_14_427 VGND VGND VPWR VPWR sky130_fd_sc_hd__fill_1
XFILLER_5_169 VPWR VGND VPWR VGND sky130_ef_sc_hd__decap_12
XFILLER_5_125 VPWR VGND VPWR VGND sky130_ef_sc_hd__decap_12
XFILLER_57_390 VGND VGND VPWR VPWR sky130_fd_sc_hd__fill_2
XFILLER_49_302 VGND VGND VPWR VPWR sky130_fd_sc_hd__fill_1
XTAP_TAPCELL_ROW_47_536 VGND VPWR sky130_fd_sc_hd__tapvpwrvgnd_1
X_0961_ net209 _0700_ _0703_ VGND VGND VPWR VPWR net85 sky130_fd_sc_hd__and3_1
XFILLER_32_213 VGND VGND VPWR VPWR sky130_fd_sc_hd__fill_2
XTAP_TAPCELL_ROW_30_403 VGND VPWR sky130_fd_sc_hd__tapvpwrvgnd_1
XFILLER_17_254 VGND VGND VPWR VPWR sky130_fd_sc_hd__fill_1
XFILLER_20_419 VGND VGND VPWR VPWR sky130_fd_sc_hd__fill_1
X_0892_ scratch\[4\]\[8\] net223 net214 scratch\[5\]\[8\] net232 VGND VGND VPWR VPWR
+ _0646_ sky130_fd_sc_hd__a221o_1
XFILLER_57_3 VPWR VGND VPWR VGND sky130_ef_sc_hd__decap_12
XFILLER_43_90 VGND VGND VPWR VPWR sky130_fd_sc_hd__fill_2
X_1375_ net147 _0378_ _0376_ scratch\[0\]\[10\] VGND VGND VPWR VPWR _0379_ sky130_fd_sc_hd__o2bb2a_1
X_1513_ scratch\[3\]\[3\] scratch\[2\]\[3\] VGND VGND VPWR VPWR _0460_ sky130_fd_sc_hd__nand2_1
X_1444_ net40 net157 _0431_ VGND VGND VPWR VPWR _0197_ sky130_fd_sc_hd__a21o_1
XFILLER_67_198 VGND VGND VPWR VPWR sky130_fd_sc_hd__decap_6
XFILLER_63_382 VGND VGND VPWR VPWR sky130_fd_sc_hd__decap_8
XFILLER_63_393 VPWR VGND VPWR VGND sky130_ef_sc_hd__decap_12
XFILLER_23_257 VPWR VGND VPWR VGND sky130_ef_sc_hd__decap_12
XFILLER_23_235 VGND VGND VPWR VPWR sky130_fd_sc_hd__fill_2
XFILLER_2_139 VGND VGND VPWR VPWR sky130_fd_sc_hd__fill_1
XFILLER_73_113 VPWR VGND VPWR VGND sky130_ef_sc_hd__decap_12
XFILLER_58_165 VGND VGND VPWR VPWR sky130_fd_sc_hd__decap_8
XFILLER_48_13 VGND VGND VPWR VPWR sky130_fd_sc_hd__fill_1
XFILLER_46_327 VGND VGND VPWR VPWR sky130_fd_sc_hd__fill_1
XFILLER_46_305 VGND VGND VPWR VPWR sky130_fd_sc_hd__decap_3
XFILLER_61_308 VGND VGND VPWR VPWR sky130_fd_sc_hd__fill_1
XTAP_TAPCELL_ROW_44_517 VGND VPWR sky130_fd_sc_hd__tapvpwrvgnd_1
XTAP_TAPCELL_ROW_1_172 VGND VPWR sky130_fd_sc_hd__tapvpwrvgnd_1
XFILLER_9_18 VPWR VGND VPWR VGND sky130_ef_sc_hd__decap_12
XTAP_TAPCELL_ROW_52_583 VGND VPWR sky130_fd_sc_hd__tapvpwrvgnd_1
XFILLER_6_401 VPWR VGND VPWR VGND sky130_ef_sc_hd__decap_12
XFILLER_6_445 VGND VGND VPWR VPWR sky130_fd_sc_hd__decap_8
XFILLER_13_93 VPWR VGND VPWR VGND sky130_ef_sc_hd__decap_12
XFILLER_1_161 VGND VGND VPWR VPWR sky130_fd_sc_hd__decap_6
X_1160_ net4 net201 net183 net25 VGND VGND VPWR VPWR _0803_ sky130_fd_sc_hd__a22o_1
X_1091_ net33 net184 net127 net326 VGND VGND VPWR VPWR _0034_ sky130_fd_sc_hd__a22o_1
X_0944_ scratch\[6\]\[17\] scratch\[7\]\[17\] net271 VGND VGND VPWR VPWR _0689_ sky130_fd_sc_hd__mux2_1
XFILLER_60_374 VPWR VGND VPWR VGND sky130_ef_sc_hd__decap_12
XFILLER_60_352 VGND VGND VPWR VPWR sky130_fd_sc_hd__fill_2
XFILLER_45_393 VGND VGND VPWR VPWR sky130_fd_sc_hd__fill_1
XTAP_TAPCELL_ROW_15_285 VGND VPWR sky130_fd_sc_hd__tapvpwrvgnd_1
X_0875_ scratch\[1\]\[6\] net214 _0630_ net255 net248 VGND VGND VPWR VPWR _0631_ sky130_fd_sc_hd__a221o_1
Xclkload20 clknet_leaf_23_clock VGND VGND VPWR VPWR clkload20/X sky130_fd_sc_hd__clkbuf_8
XFILLER_55_113 VGND VGND VPWR VPWR sky130_fd_sc_hd__decap_8
X_1358_ net49 net154 net117 _0366_ VGND VGND VPWR VPWR _0176_ sky130_fd_sc_hd__a22o_1
X_1427_ net151 _0416_ scratch\[0\]\[23\] VGND VGND VPWR VPWR _0418_ sky130_fd_sc_hd__a21oi_1
XFILLER_28_338 VPWR VGND VPWR VGND sky130_ef_sc_hd__decap_12
XFILLER_18_27 VGND VGND VPWR VPWR sky130_fd_sc_hd__fill_1
XFILLER_51_374 VGND VGND VPWR VPWR sky130_fd_sc_hd__decap_8
XFILLER_51_330 VGND VGND VPWR VPWR sky130_fd_sc_hd__decap_6
X_1289_ net247 net164 scratch\[7\]\[22\] VGND VGND VPWR VPWR _0323_ sky130_fd_sc_hd__or3b_1
XFILLER_34_59 VGND VGND VPWR VPWR sky130_fd_sc_hd__fill_1
Xclkload3 clknet_leaf_1_clock VGND VGND VPWR VPWR clkload3/Y sky130_fd_sc_hd__bufinv_16
Xfanout240 net242 VGND VGND VPWR VPWR net240 sky130_fd_sc_hd__clkbuf_2
XFILLER_74_433 VPWR VGND VPWR VGND sky130_ef_sc_hd__decap_12
XFILLER_61_105 VGND VGND VPWR VPWR sky130_fd_sc_hd__decap_6
XTAP_TAPCELL_ROW_57_620 VGND VPWR sky130_fd_sc_hd__tapvpwrvgnd_1
XFILLER_46_157 VPWR VGND VPWR VGND sky130_ef_sc_hd__decap_12
Xfanout251 net252 VGND VGND VPWR VPWR net251 sky130_fd_sc_hd__clkbuf_4
Xfanout262 net57 VGND VGND VPWR VPWR net262 sky130_fd_sc_hd__buf_2
Xfanout273 net55 VGND VGND VPWR VPWR net273 sky130_fd_sc_hd__buf_2
XTAP_TAPCELL_ROW_29_399 VGND VPWR sky130_fd_sc_hd__tapvpwrvgnd_1
XFILLER_27_393 VGND VGND VPWR VPWR sky130_fd_sc_hd__fill_1
XFILLER_6_253 VPWR VGND VPWR VGND sky130_ef_sc_hd__decap_12
X_1212_ net245 net177 scratch\[6\]\[16\] VGND VGND VPWR VPWR _0284_ sky130_fd_sc_hd__or3b_1
XFILLER_37_113 VPWR VGND VPWR VGND sky130_ef_sc_hd__decap_12
XFILLER_37_102 VGND VGND VPWR VPWR sky130_fd_sc_hd__decap_8
XTAP_TAPCELL_ROW_63_667 VGND VPWR sky130_fd_sc_hd__tapvpwrvgnd_1
X_1074_ net34 net191 net134 net350 VGND VGND VPWR VPWR _0021_ sky130_fd_sc_hd__a22o_1
XFILLER_52_149 VGND VGND VPWR VPWR sky130_fd_sc_hd__decap_3
XFILLER_33_363 VPWR VGND VPWR VGND sky130_ef_sc_hd__decap_12
X_1143_ net378 net121 _0794_ VGND VGND VPWR VPWR _0079_ sky130_fd_sc_hd__a21o_1
X_0927_ scratch\[6\]\[14\] scratch\[7\]\[14\] net266 VGND VGND VPWR VPWR _0675_ sky130_fd_sc_hd__mux2_1
XFILLER_29_15 VPWR VGND VPWR VGND sky130_ef_sc_hd__decap_12
X_0858_ scratch\[6\]\[3\] scratch\[7\]\[3\] net264 VGND VGND VPWR VPWR _0617_ sky130_fd_sc_hd__mux2_1
Xhold59 scratch\[4\]\[13\] VGND VGND VPWR VPWR net335 sky130_fd_sc_hd__dlygate4sd3_1
Xhold26 scratch\[1\]\[22\] VGND VGND VPWR VPWR net302 sky130_fd_sc_hd__dlygate4sd3_1
Xhold48 scratch\[5\]\[18\] VGND VGND VPWR VPWR net324 sky130_fd_sc_hd__dlygate4sd3_1
Xhold37 scratch\[4\]\[0\] VGND VGND VPWR VPWR net313 sky130_fd_sc_hd__dlygate4sd3_1
Xhold15 scratch\[5\]\[2\] VGND VGND VPWR VPWR net291 sky130_fd_sc_hd__dlygate4sd3_1
XFILLER_71_447 VGND VGND VPWR VPWR sky130_fd_sc_hd__fill_1
XFILLER_51_193 VGND VGND VPWR VPWR sky130_fd_sc_hd__fill_1
XTAP_TAPCELL_ROW_26_369 VGND VPWR sky130_fd_sc_hd__tapvpwrvgnd_1
XFILLER_3_223 VGND VGND VPWR VPWR sky130_fd_sc_hd__fill_1
XFILLER_66_208 VGND VGND VPWR VPWR sky130_fd_sc_hd__decap_3
XFILLER_10_83 VGND VGND VPWR VPWR sky130_fd_sc_hd__fill_1
XFILLER_10_94 VGND VGND VPWR VPWR sky130_fd_sc_hd__decap_4
XFILLER_19_113 VPWR VGND VPWR VGND sky130_ef_sc_hd__decap_12
XFILLER_34_105 VGND VGND VPWR VPWR sky130_fd_sc_hd__decap_3
XTAP_TAPCELL_ROW_17_303 VGND VPWR sky130_fd_sc_hd__tapvpwrvgnd_1
X_1761_ clknet_leaf_6_clock _0104_ VGND VGND VPWR VPWR scratch\[6\]\[7\] sky130_fd_sc_hd__dfxtp_1
XFILLER_51_90 VGND VGND VPWR VPWR sky130_fd_sc_hd__fill_1
X_1830_ clknet_leaf_25_clock _0172_ VGND VGND VPWR VPWR scratch\[0\]\[1\] sky130_fd_sc_hd__dfxtp_1
XFILLER_15_385 VGND VGND VPWR VPWR sky130_fd_sc_hd__decap_6
X_1692_ clknet_leaf_28_clock _0035_ VGND VGND VPWR VPWR scratch\[5\]\[2\] sky130_fd_sc_hd__dfxtp_1
XTAP_TAPCELL_ROW_68_704 VGND VPWR sky130_fd_sc_hd__tapvpwrvgnd_1
X_1126_ net36 net182 net123 net434 VGND VGND VPWR VPWR _0066_ sky130_fd_sc_hd__a22o_1
XFILLER_53_447 VGND VGND VPWR VPWR sky130_fd_sc_hd__fill_1
XFILLER_33_193 VGND VGND VPWR VPWR sky130_fd_sc_hd__decap_4
XFILLER_15_39 VGND VGND VPWR VPWR sky130_fd_sc_hd__fill_1
X_1057_ net47 net190 net133 net317 VGND VGND VPWR VPWR _0004_ sky130_fd_sc_hd__a22o_1
XFILLER_0_248 VGND VGND VPWR VPWR sky130_fd_sc_hd__decap_4
XFILLER_56_230 VGND VGND VPWR VPWR sky130_fd_sc_hd__decap_8
XFILLER_44_425 VGND VGND VPWR VPWR sky130_fd_sc_hd__fill_1
XTAP_TAPCELL_ROW_39_472 VGND VPWR sky130_fd_sc_hd__tapvpwrvgnd_1
XFILLER_16_149 VGND VGND VPWR VPWR sky130_fd_sc_hd__fill_2
XFILLER_12_377 VPWR VGND VPWR VGND sky130_ef_sc_hd__decap_12
XFILLER_39_208 VGND VGND VPWR VPWR sky130_fd_sc_hd__fill_2
XTAP_TAPCELL_ROW_73_751 VGND VPWR sky130_fd_sc_hd__tapvpwrvgnd_1
XFILLER_47_285 VPWR VGND VPWR VGND sky130_ef_sc_hd__decap_12
XFILLER_35_436 VGND VGND VPWR VPWR sky130_fd_sc_hd__fill_2
XFILLER_30_130 VGND VGND VPWR VPWR sky130_fd_sc_hd__decap_4
X_1744_ clknet_leaf_11_clock _0087_ VGND VGND VPWR VPWR scratch\[2\]\[11\] sky130_fd_sc_hd__dfxtp_1
X_1813_ clknet_leaf_18_clock _0156_ VGND VGND VPWR VPWR scratch\[7\]\[27\] sky130_fd_sc_hd__dfxtp_1
X_1675_ clknet_leaf_10_clock _0018_ VGND VGND VPWR VPWR scratch\[4\]\[17\] sky130_fd_sc_hd__dfxtp_1
XPHY_EDGE_ROW_15_Right_15 VGND VGND VPWR VPWR sky130_fd_sc_hd__decap_3
X_1109_ net32 net186 net129 net318 VGND VGND VPWR VPWR _0052_ sky130_fd_sc_hd__a22o_1
XFILLER_53_233 VGND VGND VPWR VPWR sky130_fd_sc_hd__decap_6
XTAP_TAPCELL_ROW_36_453 VGND VPWR sky130_fd_sc_hd__tapvpwrvgnd_1
XPHY_EDGE_ROW_24_Right_24 VGND VGND VPWR VPWR sky130_fd_sc_hd__decap_3
XFILLER_42_59 VPWR VGND VPWR VGND sky130_ef_sc_hd__decap_12
XFILLER_42_37 VPWR VGND VPWR VGND sky130_ef_sc_hd__decap_12
XFILLER_41_428 VPWR VGND VPWR VGND sky130_ef_sc_hd__decap_12
XPHY_EDGE_ROW_33_Right_33 VGND VGND VPWR VPWR sky130_fd_sc_hd__decap_3
XFILLER_5_329 VGND VGND VPWR VPWR sky130_fd_sc_hd__decap_6
XFILLER_29_263 VGND VGND VPWR VPWR sky130_fd_sc_hd__decap_8
XTAP_TAPCELL_ROW_70_721 VGND VPWR sky130_fd_sc_hd__tapvpwrvgnd_1
XPHY_EDGE_ROW_42_Right_42 VGND VGND VPWR VPWR sky130_fd_sc_hd__decap_3
XFILLER_17_425 VGND VGND VPWR VPWR sky130_fd_sc_hd__fill_1
XPHY_EDGE_ROW_51_Right_51 VGND VGND VPWR VPWR sky130_fd_sc_hd__decap_3
XFILLER_32_81 VGND VGND VPWR VPWR sky130_fd_sc_hd__decap_3
XFILLER_8_112 VGND VGND VPWR VPWR sky130_fd_sc_hd__decap_4
XFILLER_8_189 VGND VGND VPWR VPWR sky130_fd_sc_hd__decap_6
XFILLER_12_141 VGND VGND VPWR VPWR sky130_fd_sc_hd__decap_4
X_1391_ net27 net154 net120 _0390_ VGND VGND VPWR VPWR _0185_ sky130_fd_sc_hd__a22o_1
X_1460_ net46 _0347_ _0442_ scratch\[0\]\[31\] VGND VGND VPWR VPWR _0443_ sky130_fd_sc_hd__a22o_1
XPHY_EDGE_ROW_26_Left_102 VGND VGND VPWR VPWR sky130_fd_sc_hd__decap_3
XPHY_EDGE_ROW_60_Right_60 VGND VGND VPWR VPWR sky130_fd_sc_hd__decap_3
XPHY_EDGE_ROW_35_Left_111 VGND VGND VPWR VPWR sky130_fd_sc_hd__decap_3
XFILLER_50_225 VGND VGND VPWR VPWR sky130_fd_sc_hd__fill_2
XFILLER_12_18 VGND VGND VPWR VPWR sky130_fd_sc_hd__decap_8
Xhold112 scratch\[2\]\[12\] VGND VGND VPWR VPWR net388 sky130_fd_sc_hd__dlygate4sd3_1
Xhold123 scratch\[2\]\[21\] VGND VGND VPWR VPWR net399 sky130_fd_sc_hd__dlygate4sd3_1
Xhold156 scratch\[3\]\[10\] VGND VGND VPWR VPWR net432 sky130_fd_sc_hd__dlygate4sd3_1
XPHY_EDGE_ROW_44_Left_120 VGND VGND VPWR VPWR sky130_fd_sc_hd__decap_3
Xhold101 scratch\[2\]\[18\] VGND VGND VPWR VPWR net377 sky130_fd_sc_hd__dlygate4sd3_1
Xhold134 scratch\[3\]\[15\] VGND VGND VPWR VPWR net410 sky130_fd_sc_hd__dlygate4sd3_1
X_1727_ clknet_leaf_19_clock _0070_ VGND VGND VPWR VPWR scratch\[2\]\[26\] sky130_fd_sc_hd__dfxtp_1
XFILLER_12_29 VGND VGND VPWR VPWR sky130_fd_sc_hd__decap_6
X_1658_ clknet_leaf_26_clock _0001_ VGND VGND VPWR VPWR scratch\[4\]\[0\] sky130_fd_sc_hd__dfxtp_1
Xhold167 net69 VGND VGND VPWR VPWR net443 sky130_fd_sc_hd__dlygate4sd3_1
Xhold145 scratch\[3\]\[2\] VGND VGND VPWR VPWR net421 sky130_fd_sc_hd__dlygate4sd3_1
XFILLER_73_317 VPWR VGND VPWR VGND sky130_ef_sc_hd__decap_12
X_1589_ scratch\[3\]\[18\] scratch\[2\]\[18\] VGND VGND VPWR VPWR _0521_ sky130_fd_sc_hd__or2_1
XFILLER_41_236 VGND VGND VPWR VPWR sky130_fd_sc_hd__decap_3
XFILLER_41_225 VGND VGND VPWR VPWR sky130_fd_sc_hd__decap_4
XFILLER_26_288 VGND VGND VPWR VPWR sky130_fd_sc_hd__fill_1
XFILLER_5_137 VPWR VGND VPWR VGND sky130_ef_sc_hd__decap_12
XFILLER_57_380 VGND VGND VPWR VPWR sky130_fd_sc_hd__fill_1
XTAP_TAPCELL_ROW_47_537 VGND VPWR sky130_fd_sc_hd__tapvpwrvgnd_1
XFILLER_27_81 VGND VGND VPWR VPWR sky130_fd_sc_hd__decap_4
XTAP_TAPCELL_ROW_4_192 VGND VPWR sky130_fd_sc_hd__tapvpwrvgnd_1
X_0960_ net260 _0701_ _0702_ VGND VGND VPWR VPWR _0703_ sky130_fd_sc_hd__a21o_1
XFILLER_32_269 VGND VGND VPWR VPWR sky130_fd_sc_hd__fill_1
XFILLER_32_236 VPWR VGND VPWR VGND sky130_ef_sc_hd__decap_12
XTAP_TAPCELL_ROW_30_404 VGND VPWR sky130_fd_sc_hd__tapvpwrvgnd_1
XFILLER_17_266 VGND VGND VPWR VPWR sky130_fd_sc_hd__decap_3
X_0891_ scratch\[6\]\[8\] scratch\[7\]\[8\] net265 VGND VGND VPWR VPWR _0645_ sky130_fd_sc_hd__mux2_1
Xclkbuf_leaf_13_clock clknet_2_3__leaf_clock VGND VGND VPWR VPWR clknet_leaf_13_clock
+ sky130_fd_sc_hd__clkbuf_8
XFILLER_40_291 VGND VGND VPWR VPWR sky130_fd_sc_hd__fill_1
X_1512_ net309 net108 _0459_ VGND VGND VPWR VPWR _0237_ sky130_fd_sc_hd__a21o_1
XFILLER_67_111 VGND VGND VPWR VPWR sky130_fd_sc_hd__fill_1
X_1374_ scratch\[0\]\[8\] scratch\[0\]\[9\] scratch\[0\]\[10\] net204 VGND VGND VPWR
+ VPWR _0378_ sky130_fd_sc_hd__and4_1
X_1443_ _0420_ _0429_ _0427_ net118 VGND VGND VPWR VPWR _0431_ sky130_fd_sc_hd__o211a_1
XFILLER_4_85 VPWR VGND VPWR VGND sky130_ef_sc_hd__decap_12
XFILLER_4_41 VPWR VGND VPWR VGND sky130_ef_sc_hd__decap_12
Xclkbuf_leaf_28_clock clknet_2_0__leaf_clock VGND VGND VPWR VPWR clknet_leaf_28_clock
+ sky130_fd_sc_hd__clkbuf_8
XFILLER_70_309 VPWR VGND VPWR VGND sky130_ef_sc_hd__decap_12
XFILLER_23_225 VGND VGND VPWR VPWR sky130_fd_sc_hd__decap_4
XFILLER_23_269 VGND VGND VPWR VPWR sky130_fd_sc_hd__decap_8
XFILLER_73_125 VPWR VGND VPWR VGND sky130_ef_sc_hd__decap_12
XFILLER_48_36 VGND VGND VPWR VPWR sky130_fd_sc_hd__decap_3
XFILLER_46_339 VGND VGND VPWR VPWR sky130_fd_sc_hd__decap_8
XFILLER_39_380 VPWR VGND VPWR VGND sky130_ef_sc_hd__decap_12
XFILLER_73_169 VPWR VGND VPWR VGND sky130_ef_sc_hd__decap_12
XTAP_TAPCELL_ROW_44_518 VGND VPWR sky130_fd_sc_hd__tapvpwrvgnd_1
XTAP_TAPCELL_ROW_1_173 VGND VPWR sky130_fd_sc_hd__tapvpwrvgnd_1
XFILLER_6_413 VGND VGND VPWR VPWR sky130_fd_sc_hd__decap_6
XFILLER_49_111 VGND VGND VPWR VPWR sky130_fd_sc_hd__fill_1
XFILLER_52_309 VPWR VGND VPWR VGND sky130_ef_sc_hd__decap_12
X_1090_ net22 net184 net127 net320 VGND VGND VPWR VPWR _0033_ sky130_fd_sc_hd__a22o_1
XFILLER_60_386 VPWR VGND VPWR VGND sky130_ef_sc_hd__decap_12
X_0943_ scratch\[0\]\[17\] scratch\[2\]\[17\] scratch\[1\]\[17\] scratch\[3\]\[17\]
+ net261 net271 VGND VGND VPWR VPWR _0688_ sky130_fd_sc_hd__mux4_1
Xclkload10 clknet_leaf_3_clock VGND VGND VPWR VPWR clkload10/Y sky130_fd_sc_hd__inv_8
X_0874_ scratch\[2\]\[6\] scratch\[3\]\[6\] net265 VGND VGND VPWR VPWR _0630_ sky130_fd_sc_hd__mux2_1
XTAP_TAPCELL_ROW_15_286 VGND VPWR sky130_fd_sc_hd__tapvpwrvgnd_1
Xclkload21 clknet_leaf_9_clock VGND VGND VPWR VPWR clkload21/Y sky130_fd_sc_hd__clkinv_2
X_1288_ net35 net167 _0322_ VGND VGND VPWR VPWR _0150_ sky130_fd_sc_hd__a21bo_1
X_1357_ net147 _0365_ _0363_ scratch\[0\]\[5\] VGND VGND VPWR VPWR _0366_ sky130_fd_sc_hd__o2bb2a_1
X_1426_ net36 net158 net119 _0417_ VGND VGND VPWR VPWR _0193_ sky130_fd_sc_hd__a22o_1
XFILLER_70_139 VGND VGND VPWR VPWR sky130_fd_sc_hd__fill_1
Xclkload4 clknet_leaf_24_clock VGND VGND VPWR VPWR clkload4/X sky130_fd_sc_hd__clkbuf_4
XFILLER_3_405 VPWR VGND VPWR VGND sky130_ef_sc_hd__decap_12
XFILLER_59_57 VPWR VGND VPWR VGND sky130_ef_sc_hd__decap_12
Xfanout241 net242 VGND VGND VPWR VPWR net241 sky130_fd_sc_hd__clkbuf_2
Xfanout230 _0587_ VGND VGND VPWR VPWR net230 sky130_fd_sc_hd__dlymetal6s2s_1
Xfanout274 net275 VGND VGND VPWR VPWR net274 sky130_fd_sc_hd__dlymetal6s2s_1
Xfanout252 net58 VGND VGND VPWR VPWR net252 sky130_fd_sc_hd__clkbuf_4
XFILLER_3_449 VGND VGND VPWR VPWR sky130_fd_sc_hd__decap_4
XTAP_TAPCELL_ROW_6_210 VGND VPWR sky130_fd_sc_hd__tapvpwrvgnd_1
Xfanout263 net264 VGND VGND VPWR VPWR net263 sky130_fd_sc_hd__clkbuf_4
XFILLER_74_445 VGND VGND VPWR VPWR sky130_fd_sc_hd__decap_8
XFILLER_74_401 VPWR VGND VPWR VGND sky130_ef_sc_hd__decap_12
XTAP_TAPCELL_ROW_57_621 VGND VPWR sky130_fd_sc_hd__tapvpwrvgnd_1
XFILLER_54_180 VPWR VGND VPWR VGND sky130_ef_sc_hd__decap_12
XFILLER_46_169 VPWR VGND VPWR VGND sky130_ef_sc_hd__decap_12
XFILLER_24_71 VPWR VGND VPWR VGND sky130_ef_sc_hd__decap_12
XTAP_TAPCELL_ROW_12_256 VGND VPWR sky130_fd_sc_hd__tapvpwrvgnd_1
XFILLER_69_217 VGND VGND VPWR VPWR sky130_fd_sc_hd__decap_6
XFILLER_6_221 VPWR VGND VPWR VGND sky130_ef_sc_hd__decap_12
XFILLER_6_265 VPWR VGND VPWR VGND sky130_ef_sc_hd__decap_12
XFILLER_49_90 VGND VGND VPWR VPWR sky130_fd_sc_hd__decap_8
XFILLER_37_125 VGND VGND VPWR VPWR sky130_fd_sc_hd__decap_4
X_1142_ net15 net195 net179 net47 VGND VGND VPWR VPWR _0794_ sky130_fd_sc_hd__a22o_1
X_1211_ net28 net174 _0283_ VGND VGND VPWR VPWR _0112_ sky130_fd_sc_hd__a21bo_1
XTAP_TAPCELL_ROW_63_668 VGND VPWR sky130_fd_sc_hd__tapvpwrvgnd_1
X_1073_ net32 net191 net134 net321 VGND VGND VPWR VPWR _0020_ sky130_fd_sc_hd__a22o_1
XFILLER_33_375 VPWR VGND VPWR VGND sky130_ef_sc_hd__decap_12
XFILLER_33_331 VGND VGND VPWR VPWR sky130_fd_sc_hd__decap_4
XFILLER_25_309 VGND VGND VPWR VPWR sky130_fd_sc_hd__fill_2
X_0926_ scratch\[0\]\[14\] scratch\[2\]\[14\] scratch\[1\]\[14\] scratch\[3\]\[14\]
+ net257 net266 VGND VGND VPWR VPWR _0674_ sky130_fd_sc_hd__mux4_1
X_0857_ net254 _0614_ _0615_ VGND VGND VPWR VPWR _0616_ sky130_fd_sc_hd__a21o_1
XFILLER_20_29 VGND VGND VPWR VPWR sky130_fd_sc_hd__fill_1
Xhold27 scratch\[1\]\[7\] VGND VGND VPWR VPWR net303 sky130_fd_sc_hd__dlygate4sd3_1
Xhold38 scratch\[5\]\[17\] VGND VGND VPWR VPWR net314 sky130_fd_sc_hd__dlygate4sd3_1
X_1409_ _0403_ _0404_ VGND VGND VPWR VPWR _0405_ sky130_fd_sc_hd__nor2_1
XFILLER_29_27 VGND VGND VPWR VPWR sky130_fd_sc_hd__decap_4
Xhold16 scratch\[1\]\[25\] VGND VGND VPWR VPWR net292 sky130_fd_sc_hd__dlygate4sd3_1
XFILLER_45_37 VGND VGND VPWR VPWR sky130_fd_sc_hd__decap_3
XFILLER_43_139 VGND VGND VPWR VPWR sky130_fd_sc_hd__decap_8
XFILLER_16_309 VGND VGND VPWR VPWR sky130_fd_sc_hd__fill_1
Xhold49 scratch\[4\]\[29\] VGND VGND VPWR VPWR net325 sky130_fd_sc_hd__dlygate4sd3_1
Xclkbuf_2_2__f_clock clknet_0_clock VGND VGND VPWR VPWR clknet_2_2__leaf_clock sky130_fd_sc_hd__clkbuf_16
XFILLER_47_445 VGND VGND VPWR VPWR sky130_fd_sc_hd__decap_3
XFILLER_47_412 VPWR VGND VPWR VGND sky130_ef_sc_hd__decap_12
XFILLER_3_279 VGND VGND VPWR VPWR sky130_fd_sc_hd__fill_1
XFILLER_19_125 VPWR VGND VPWR VGND sky130_ef_sc_hd__decap_12
XFILLER_74_253 VPWR VGND VPWR VGND sky130_ef_sc_hd__decap_12
XFILLER_19_169 VGND VGND VPWR VPWR sky130_fd_sc_hd__decap_6
X_1760_ clknet_leaf_4_clock _0103_ VGND VGND VPWR VPWR scratch\[6\]\[6\] sky130_fd_sc_hd__dfxtp_1
X_1691_ clknet_leaf_27_clock _0034_ VGND VGND VPWR VPWR scratch\[5\]\[1\] sky130_fd_sc_hd__dfxtp_1
XTAP_TAPCELL_ROW_68_705 VGND VPWR sky130_fd_sc_hd__tapvpwrvgnd_1
XFILLER_53_415 VPWR VGND VPWR VGND sky130_ef_sc_hd__decap_12
X_1125_ net35 net183 net125 net399 VGND VGND VPWR VPWR _0065_ sky130_fd_sc_hd__a22o_1
X_1056_ net44 net190 net133 net297 VGND VGND VPWR VPWR _0003_ sky130_fd_sc_hd__a22o_1
XFILLER_21_389 VGND VGND VPWR VPWR sky130_fd_sc_hd__decap_3
X_0909_ scratch\[1\]\[11\] net219 _0659_ VGND VGND VPWR VPWR _0660_ sky130_fd_sc_hd__a21o_1
X_1889_ clknet_leaf_17_clock _0231_ VGND VGND VPWR VPWR scratch\[3\]\[28\] sky130_fd_sc_hd__dfxtp_1
XFILLER_56_220 VGND VGND VPWR VPWR sky130_fd_sc_hd__decap_4
XFILLER_71_223 VGND VGND VPWR VPWR sky130_fd_sc_hd__fill_1
XFILLER_56_253 VPWR VGND VPWR VGND sky130_ef_sc_hd__decap_12
XFILLER_44_448 VGND VGND VPWR VPWR sky130_fd_sc_hd__decap_4
XTAP_TAPCELL_ROW_39_473 VGND VPWR sky130_fd_sc_hd__tapvpwrvgnd_1
XFILLER_24_194 VGND VGND VPWR VPWR sky130_fd_sc_hd__fill_2
XTAP_TAPCELL_ROW_22_340 VGND VPWR sky130_fd_sc_hd__tapvpwrvgnd_1
XFILLER_8_305 VGND VGND VPWR VPWR sky130_fd_sc_hd__decap_3
XFILLER_12_389 VPWR VGND VPWR VGND sky130_ef_sc_hd__decap_12
XFILLER_47_297 VPWR VGND VPWR VGND sky130_ef_sc_hd__decap_12
XFILLER_62_289 VPWR VGND VPWR VGND sky130_ef_sc_hd__decap_12
XFILLER_50_418 VGND VGND VPWR VPWR sky130_fd_sc_hd__fill_2
XFILLER_22_109 VGND VGND VPWR VPWR sky130_fd_sc_hd__fill_1
X_1743_ clknet_leaf_8_clock _0086_ VGND VGND VPWR VPWR scratch\[2\]\[10\] sky130_fd_sc_hd__dfxtp_1
X_1674_ clknet_leaf_9_clock _0017_ VGND VGND VPWR VPWR scratch\[4\]\[16\] sky130_fd_sc_hd__dfxtp_1
XFILLER_30_197 VGND VGND VPWR VPWR sky130_fd_sc_hd__fill_2
X_1812_ clknet_leaf_19_clock _0155_ VGND VGND VPWR VPWR scratch\[7\]\[26\] sky130_fd_sc_hd__dfxtp_1
XFILLER_7_30 VPWR VGND VPWR VGND sky130_ef_sc_hd__decap_12
XFILLER_7_393 VPWR VGND VPWR VGND sky130_ef_sc_hd__decap_12
XFILLER_53_267 VGND VGND VPWR VPWR sky130_fd_sc_hd__fill_1
XFILLER_41_407 VPWR VGND VPWR VGND sky130_ef_sc_hd__decap_12
XFILLER_38_253 VPWR VGND VPWR VGND sky130_ef_sc_hd__decap_12
XFILLER_38_242 VGND VGND VPWR VPWR sky130_fd_sc_hd__decap_8
XTAP_TAPCELL_ROW_36_454 VGND VPWR sky130_fd_sc_hd__tapvpwrvgnd_1
X_1108_ net31 net187 net130 net324 VGND VGND VPWR VPWR _0051_ sky130_fd_sc_hd__a22o_1
X_1039_ cycle_count\[2\] _0583_ _0768_ VGND VGND VPWR VPWR _0769_ sky130_fd_sc_hd__or3_1
XFILLER_42_49 VGND VGND VPWR VPWR sky130_fd_sc_hd__fill_1
XFILLER_42_27 VGND VGND VPWR VPWR sky130_fd_sc_hd__fill_1
XFILLER_67_57 VPWR VGND VPWR VGND sky130_ef_sc_hd__decap_12
XFILLER_29_253 VGND VGND VPWR VPWR sky130_fd_sc_hd__decap_3
XTAP_TAPCELL_ROW_70_722 VGND VPWR sky130_fd_sc_hd__tapvpwrvgnd_1
XFILLER_32_407 VPWR VGND VPWR VGND sky130_ef_sc_hd__decap_12
XFILLER_32_93 VGND VGND VPWR VPWR sky130_fd_sc_hd__fill_2
XFILLER_8_124 VPWR VGND VPWR VGND sky130_ef_sc_hd__decap_12
XFILLER_12_197 VGND VGND VPWR VPWR sky130_fd_sc_hd__fill_2
XFILLER_67_337 VGND VGND VPWR VPWR sky130_fd_sc_hd__decap_8
X_1390_ net148 _0389_ _0387_ scratch\[0\]\[14\] VGND VGND VPWR VPWR _0390_ sky130_fd_sc_hd__o2bb2a_1
XFILLER_4_363 VGND VGND VPWR VPWR sky130_fd_sc_hd__fill_1
XFILLER_35_278 VGND VGND VPWR VPWR sky130_fd_sc_hd__fill_2
XTAP_TAPCELL_ROW_41_490 VGND VPWR sky130_fd_sc_hd__tapvpwrvgnd_1
XTAP_TAPCELL_ROW_33_424 VGND VPWR sky130_fd_sc_hd__tapvpwrvgnd_1
XFILLER_31_440 VGND VGND VPWR VPWR sky130_fd_sc_hd__decap_8
Xhold157 scratch\[3\]\[14\] VGND VGND VPWR VPWR net433 sky130_fd_sc_hd__dlygate4sd3_1
Xhold135 scratch\[3\]\[12\] VGND VGND VPWR VPWR net411 sky130_fd_sc_hd__dlygate4sd3_1
Xhold113 scratch\[2\]\[10\] VGND VGND VPWR VPWR net389 sky130_fd_sc_hd__dlygate4sd3_1
Xhold146 scratch\[3\]\[16\] VGND VGND VPWR VPWR net422 sky130_fd_sc_hd__dlygate4sd3_1
X_1588_ scratch\[3\]\[18\] scratch\[2\]\[18\] VGND VGND VPWR VPWR _0520_ sky130_fd_sc_hd__nand2_1
Xhold102 scratch\[2\]\[3\] VGND VGND VPWR VPWR net378 sky130_fd_sc_hd__dlygate4sd3_1
Xhold124 scratch\[2\]\[28\] VGND VGND VPWR VPWR net400 sky130_fd_sc_hd__dlygate4sd3_1
X_1726_ clknet_leaf_23_clock _0069_ VGND VGND VPWR VPWR scratch\[2\]\[25\] sky130_fd_sc_hd__dfxtp_1
X_1657_ net301 net108 _0575_ VGND VGND VPWR VPWR _0266_ sky130_fd_sc_hd__a21o_1
XFILLER_73_329 VGND VGND VPWR VPWR sky130_fd_sc_hd__decap_6
XFILLER_26_234 VGND VGND VPWR VPWR sky130_fd_sc_hd__decap_8
XFILLER_5_149 VPWR VGND VPWR VGND sky130_ef_sc_hd__decap_12
XFILLER_5_105 VGND VGND VPWR VPWR sky130_fd_sc_hd__decap_6
XFILLER_49_348 VGND VGND VPWR VPWR sky130_fd_sc_hd__decap_6
Xclkbuf_leaf_9_clock clknet_2_3__leaf_clock VGND VGND VPWR VPWR clknet_leaf_9_clock
+ sky130_fd_sc_hd__clkbuf_8
XTAP_TAPCELL_ROW_47_538 VGND VPWR sky130_fd_sc_hd__tapvpwrvgnd_1
XTAP_TAPCELL_ROW_4_193 VGND VPWR sky130_fd_sc_hd__tapvpwrvgnd_1
X_0890_ scratch\[1\]\[8\] net214 _0643_ VGND VGND VPWR VPWR _0644_ sky130_fd_sc_hd__a21o_1
XFILLER_32_248 VGND VGND VPWR VPWR sky130_fd_sc_hd__decap_4
XTAP_TAPCELL_ROW_30_405 VGND VPWR sky130_fd_sc_hd__tapvpwrvgnd_1
XFILLER_17_289 VPWR VGND VPWR VGND sky130_ef_sc_hd__decap_12
X_1442_ net153 _0421_ _0428_ VGND VGND VPWR VPWR _0430_ sky130_fd_sc_hd__and3_1
X_1511_ net44 _0458_ net137 VGND VGND VPWR VPWR _0459_ sky130_fd_sc_hd__mux2_1
XFILLER_67_167 VGND VGND VPWR VPWR sky130_fd_sc_hd__fill_1
X_1373_ net53 net154 _0377_ VGND VGND VPWR VPWR _0180_ sky130_fd_sc_hd__a21o_1
XFILLER_4_97 VPWR VGND VPWR VGND sky130_ef_sc_hd__decap_12
XFILLER_4_53 VPWR VGND VPWR VGND sky130_ef_sc_hd__decap_12
XFILLER_31_281 VGND VGND VPWR VPWR sky130_fd_sc_hd__decap_8
XFILLER_58_123 VGND VGND VPWR VPWR sky130_fd_sc_hd__fill_1
X_1709_ clknet_leaf_12_clock _0052_ VGND VGND VPWR VPWR scratch\[5\]\[19\] sky130_fd_sc_hd__dfxtp_1
XPHY_EDGE_ROW_18_Left_94 VGND VGND VPWR VPWR sky130_fd_sc_hd__decap_3
XFILLER_73_137 VPWR VGND VPWR VGND sky130_ef_sc_hd__decap_12
XTAP_TAPCELL_ROW_44_519 VGND VPWR sky130_fd_sc_hd__tapvpwrvgnd_1
XTAP_TAPCELL_ROW_1_174 VGND VPWR sky130_fd_sc_hd__tapvpwrvgnd_1
XFILLER_10_421 VPWR VGND VPWR VGND sky130_ef_sc_hd__decap_12
XFILLER_14_248 VGND VGND VPWR VPWR sky130_fd_sc_hd__decap_4
XPHY_EDGE_ROW_63_Left_139 VGND VGND VPWR VPWR sky130_fd_sc_hd__decap_3
XFILLER_49_189 VPWR VGND VPWR VGND sky130_ef_sc_hd__decap_12
XFILLER_49_167 VGND VGND VPWR VPWR sky130_fd_sc_hd__fill_1
XFILLER_37_329 VGND VGND VPWR VPWR sky130_fd_sc_hd__decap_6
XFILLER_29_9 VGND VGND VPWR VPWR sky130_fd_sc_hd__fill_2
XPHY_EDGE_ROW_72_Left_148 VGND VGND VPWR VPWR sky130_fd_sc_hd__decap_3
XFILLER_64_126 VPWR VGND VPWR VGND sky130_ef_sc_hd__decap_12
XFILLER_60_332 VPWR VGND VPWR VGND sky130_ef_sc_hd__decap_12
XFILLER_45_340 VGND VGND VPWR VPWR sky130_fd_sc_hd__decap_6
XFILLER_60_398 VPWR VGND VPWR VGND sky130_ef_sc_hd__decap_12
Xclkload22 clknet_leaf_10_clock VGND VGND VPWR VPWR clkload22/Y sky130_fd_sc_hd__clkinvlp_4
X_0873_ net248 _0626_ _0628_ _0629_ net207 VGND VGND VPWR VPWR net102 sky130_fd_sc_hd__o221a_1
X_0942_ net251 _0684_ _0686_ _0687_ net209 VGND VGND VPWR VPWR net82 sky130_fd_sc_hd__o221a_1
Xclkload11 clknet_leaf_4_clock VGND VGND VPWR VPWR clkload11/Y sky130_fd_sc_hd__inv_6
XFILLER_13_281 VGND VGND VPWR VPWR sky130_fd_sc_hd__decap_4
XTAP_TAPCELL_ROW_15_287 VGND VPWR sky130_fd_sc_hd__tapvpwrvgnd_1
XFILLER_68_421 VPWR VGND VPWR VGND sky130_ef_sc_hd__decap_12
X_1425_ net151 _0416_ _0413_ scratch\[0\]\[22\] VGND VGND VPWR VPWR _0417_ sky130_fd_sc_hd__o2bb2a_1
XTAP_TAPCELL_ROW_66_688 VGND VPWR sky130_fd_sc_hd__tapvpwrvgnd_1
XFILLER_55_104 VGND VGND VPWR VPWR sky130_fd_sc_hd__decap_8
X_1287_ net246 net167 scratch\[7\]\[21\] VGND VGND VPWR VPWR _0322_ sky130_fd_sc_hd__or3b_1
X_1356_ scratch\[0\]\[4\] scratch\[0\]\[5\] _0360_ VGND VGND VPWR VPWR _0365_ sky130_fd_sc_hd__and3_1
XFILLER_36_362 VGND VGND VPWR VPWR sky130_fd_sc_hd__fill_2
XFILLER_18_29 VGND VGND VPWR VPWR sky130_fd_sc_hd__decap_8
Xclkload5 clknet_leaf_25_clock VGND VGND VPWR VPWR clkload5/X sky130_fd_sc_hd__clkbuf_4
XFILLER_3_417 VPWR VGND VPWR VGND sky130_ef_sc_hd__decap_12
XFILLER_74_413 VGND VGND VPWR VPWR sky130_fd_sc_hd__decap_6
XFILLER_59_69 VPWR VGND VPWR VGND sky130_ef_sc_hd__decap_12
Xfanout220 net221 VGND VGND VPWR VPWR net220 sky130_fd_sc_hd__dlymetal6s2s_1
Xfanout275 net14 VGND VGND VPWR VPWR net275 sky130_fd_sc_hd__buf_1
XPHY_EDGE_ROW_3_Left_79 VGND VGND VPWR VPWR sky130_fd_sc_hd__decap_3
XTAP_TAPCELL_ROW_6_211 VGND VPWR sky130_fd_sc_hd__tapvpwrvgnd_1
Xfanout242 net66 VGND VGND VPWR VPWR net242 sky130_fd_sc_hd__buf_2
Xfanout264 net267 VGND VGND VPWR VPWR net264 sky130_fd_sc_hd__clkbuf_4
Xfanout253 net254 VGND VGND VPWR VPWR net253 sky130_fd_sc_hd__buf_2
Xfanout231 net235 VGND VGND VPWR VPWR net231 sky130_fd_sc_hd__buf_2
XFILLER_75_57 VPWR VGND VPWR VGND sky130_ef_sc_hd__decap_12
Xclkbuf_leaf_12_clock clknet_2_3__leaf_clock VGND VGND VPWR VPWR clknet_leaf_12_clock
+ sky130_fd_sc_hd__clkbuf_8
XTAP_TAPCELL_ROW_57_622 VGND VPWR sky130_fd_sc_hd__tapvpwrvgnd_1
XFILLER_54_192 VGND VGND VPWR VPWR sky130_fd_sc_hd__decap_4
XFILLER_46_148 VGND VGND VPWR VPWR sky130_fd_sc_hd__fill_1
XFILLER_42_332 VPWR VGND VPWR VGND sky130_ef_sc_hd__decap_12
XFILLER_42_365 VGND VGND VPWR VPWR sky130_fd_sc_hd__fill_1
XFILLER_24_83 VGND VGND VPWR VPWR sky130_fd_sc_hd__fill_1
XFILLER_6_233 VPWR VGND VPWR VGND sky130_ef_sc_hd__decap_12
XFILLER_10_251 VGND VGND VPWR VPWR sky130_fd_sc_hd__fill_1
XFILLER_10_284 VGND VGND VPWR VPWR sky130_fd_sc_hd__fill_2
XTAP_TAPCELL_ROW_12_257 VGND VPWR sky130_fd_sc_hd__tapvpwrvgnd_1
Xclkbuf_leaf_27_clock clknet_2_0__leaf_clock VGND VGND VPWR VPWR clknet_leaf_27_clock
+ sky130_fd_sc_hd__clkbuf_8
XFILLER_6_277 VPWR VGND VPWR VGND sky130_ef_sc_hd__decap_12
X_1072_ net31 net192 net135 net349 VGND VGND VPWR VPWR _0019_ sky130_fd_sc_hd__a22o_1
X_1141_ net375 net121 _0793_ VGND VGND VPWR VPWR _0078_ sky130_fd_sc_hd__a21o_1
X_1210_ net244 net174 scratch\[6\]\[15\] VGND VGND VPWR VPWR _0283_ sky130_fd_sc_hd__or3b_1
XTAP_TAPCELL_ROW_63_669 VGND VPWR sky130_fd_sc_hd__tapvpwrvgnd_1
XFILLER_45_181 VGND VGND VPWR VPWR sky130_fd_sc_hd__fill_1
XFILLER_33_387 VGND VGND VPWR VPWR sky130_fd_sc_hd__decap_4
XTAP_TAPCELL_ROW_28_390 VGND VPWR sky130_fd_sc_hd__tapvpwrvgnd_1
X_0925_ net207 _0670_ _0673_ VGND VGND VPWR VPWR net79 sky130_fd_sc_hd__and3_1
X_0856_ scratch\[0\]\[3\] net222 net213 scratch\[1\]\[3\] net249 VGND VGND VPWR VPWR
+ _0615_ sky130_fd_sc_hd__a221o_1
XFILLER_68_240 VGND VGND VPWR VPWR sky130_fd_sc_hd__fill_1
Xhold17 scratch\[1\]\[19\] VGND VGND VPWR VPWR net293 sky130_fd_sc_hd__dlygate4sd3_1
Xhold28 scratch\[1\]\[9\] VGND VGND VPWR VPWR net304 sky130_fd_sc_hd__dlygate4sd3_1
Xhold39 scratch\[4\]\[17\] VGND VGND VPWR VPWR net315 sky130_fd_sc_hd__dlygate4sd3_1
X_1408_ scratch\[0\]\[18\] net150 _0401_ VGND VGND VPWR VPWR _0404_ sky130_fd_sc_hd__and3_1
XFILLER_71_449 VGND VGND VPWR VPWR sky130_fd_sc_hd__decap_4
XFILLER_71_405 VPWR VGND VPWR VGND sky130_ef_sc_hd__decap_12
XFILLER_36_192 VGND VGND VPWR VPWR sky130_fd_sc_hd__decap_4
XFILLER_24_321 VPWR VGND VPWR VGND sky130_ef_sc_hd__decap_12
X_1339_ scratch\[0\]\[0\] scratch\[0\]\[1\] VGND VGND VPWR VPWR _0352_ sky130_fd_sc_hd__or2_1
XFILLER_61_15 VPWR VGND VPWR VGND sky130_ef_sc_hd__decap_12
XFILLER_24_365 VPWR VGND VPWR VGND sky130_ef_sc_hd__decap_12
XFILLER_3_225 VPWR VGND VPWR VGND sky130_ef_sc_hd__decap_12
XFILLER_10_41 VPWR VGND VPWR VGND sky130_ef_sc_hd__decap_12
XFILLER_10_85 VGND VGND VPWR VPWR sky130_fd_sc_hd__fill_1
XFILLER_74_265 VPWR VGND VPWR VGND sky130_ef_sc_hd__decap_12
XFILLER_74_221 VPWR VGND VPWR VGND sky130_ef_sc_hd__decap_12
XFILLER_62_405 VPWR VGND VPWR VGND sky130_ef_sc_hd__decap_12
XFILLER_47_424 VPWR VGND VPWR VGND sky130_ef_sc_hd__decap_12
XFILLER_19_137 VGND VGND VPWR VPWR sky130_fd_sc_hd__decap_4
XFILLER_35_93 VPWR VGND VPWR VGND sky130_ef_sc_hd__decap_12
XTAP_TAPCELL_ROW_25_360 VGND VPWR sky130_fd_sc_hd__tapvpwrvgnd_1
XFILLER_15_332 VGND VGND VPWR VPWR sky130_fd_sc_hd__decap_4
X_1690_ clknet_leaf_26_clock _0033_ VGND VGND VPWR VPWR scratch\[5\]\[0\] sky130_fd_sc_hd__dfxtp_1
XTAP_TAPCELL_ROW_68_706 VGND VPWR sky130_fd_sc_hd__tapvpwrvgnd_1
XFILLER_65_232 VPWR VGND VPWR VGND sky130_ef_sc_hd__decap_12
XFILLER_53_449 VGND VGND VPWR VPWR sky130_fd_sc_hd__fill_1
XFILLER_53_427 VGND VGND VPWR VPWR sky130_fd_sc_hd__decap_6
X_1124_ _0788_ net179 VGND VGND VPWR VPWR _0790_ sky130_fd_sc_hd__nor2_1
X_1055_ net33 net190 net133 net355 VGND VGND VPWR VPWR _0002_ sky130_fd_sc_hd__a22o_1
XFILLER_21_335 VGND VGND VPWR VPWR sky130_fd_sc_hd__fill_1
X_0908_ scratch\[0\]\[11\] net228 _0658_ net261 net251 VGND VGND VPWR VPWR _0659_
+ sky130_fd_sc_hd__a221o_1
X_1888_ clknet_leaf_17_clock _0230_ VGND VGND VPWR VPWR scratch\[3\]\[27\] sky130_fd_sc_hd__dfxtp_1
X_0839_ _0599_ _0600_ VGND VGND VPWR VPWR _0601_ sky130_fd_sc_hd__nor2_1
XFILLER_56_265 VPWR VGND VPWR VGND sky130_ef_sc_hd__decap_12
XFILLER_56_59 VGND VGND VPWR VPWR sky130_fd_sc_hd__decap_4
XFILLER_29_424 VPWR VGND VPWR VGND sky130_ef_sc_hd__decap_12
XFILLER_71_279 VGND VGND VPWR VPWR sky130_fd_sc_hd__fill_1
XTAP_TAPCELL_ROW_39_474 VGND VPWR sky130_fd_sc_hd__tapvpwrvgnd_1
XTAP_TAPCELL_ROW_22_341 VGND VPWR sky130_fd_sc_hd__tapvpwrvgnd_1
XFILLER_62_246 VGND VGND VPWR VPWR sky130_fd_sc_hd__decap_6
XFILLER_47_254 VGND VGND VPWR VPWR sky130_fd_sc_hd__fill_1
XPHY_EDGE_ROW_6_Left_82 VGND VGND VPWR VPWR sky130_fd_sc_hd__decap_3
XFILLER_50_408 VGND VGND VPWR VPWR sky130_fd_sc_hd__fill_2
X_1811_ clknet_leaf_19_clock _0154_ VGND VGND VPWR VPWR scratch\[7\]\[25\] sky130_fd_sc_hd__dfxtp_1
X_1742_ clknet_leaf_7_clock _0085_ VGND VGND VPWR VPWR scratch\[2\]\[9\] sky130_fd_sc_hd__dfxtp_1
XFILLER_7_42 VPWR VGND VPWR VGND sky130_ef_sc_hd__decap_12
XFILLER_7_361 VPWR VGND VPWR VGND sky130_ef_sc_hd__decap_12
X_1673_ clknet_leaf_22_clock _0016_ VGND VGND VPWR VPWR scratch\[4\]\[15\] sky130_fd_sc_hd__dfxtp_1
X_1107_ net30 net186 net129 net314 VGND VGND VPWR VPWR _0050_ sky130_fd_sc_hd__a22o_1
XFILLER_53_279 VGND VGND VPWR VPWR sky130_fd_sc_hd__fill_1
XFILLER_41_419 VGND VGND VPWR VPWR sky130_fd_sc_hd__decap_3
XFILLER_38_265 VGND VGND VPWR VPWR sky130_fd_sc_hd__decap_8
XTAP_TAPCELL_ROW_36_455 VGND VPWR sky130_fd_sc_hd__tapvpwrvgnd_1
X_1038_ net276 net274 VGND VGND VPWR VPWR _0768_ sky130_fd_sc_hd__or2_1
XFILLER_26_29 VGND VGND VPWR VPWR sky130_fd_sc_hd__decap_8
XPHY_EDGE_ROW_5_Right_5 VGND VGND VPWR VPWR sky130_fd_sc_hd__decap_3
XFILLER_67_69 VPWR VGND VPWR VGND sky130_ef_sc_hd__decap_12
XFILLER_44_213 VGND VGND VPWR VPWR sky130_fd_sc_hd__fill_1
XFILLER_17_438 VGND VGND VPWR VPWR sky130_fd_sc_hd__decap_8
XFILLER_17_449 VGND VGND VPWR VPWR sky130_fd_sc_hd__decap_4
XTAP_TAPCELL_ROW_70_723 VGND VPWR sky130_fd_sc_hd__tapvpwrvgnd_1
XFILLER_32_419 VGND VGND VPWR VPWR sky130_fd_sc_hd__fill_1
XFILLER_8_136 VGND VGND VPWR VPWR sky130_fd_sc_hd__decap_4
XFILLER_32_50 VPWR VGND VPWR VGND sky130_ef_sc_hd__decap_12
XFILLER_67_305 VGND VGND VPWR VPWR sky130_fd_sc_hd__fill_2
XFILLER_57_80 VPWR VGND VPWR VGND sky130_ef_sc_hd__decap_12
XFILLER_75_393 VPWR VGND VPWR VGND sky130_ef_sc_hd__decap_12
XFILLER_75_360 VGND VGND VPWR VPWR sky130_fd_sc_hd__decap_4
XFILLER_50_205 VPWR VGND VPWR VGND sky130_ef_sc_hd__decap_12
XFILLER_35_235 VGND VGND VPWR VPWR sky130_fd_sc_hd__fill_1
XFILLER_35_202 VGND VGND VPWR VPWR sky130_fd_sc_hd__decap_3
XTAP_TAPCELL_ROW_33_425 VGND VPWR sky130_fd_sc_hd__tapvpwrvgnd_1
XTAP_TAPCELL_ROW_41_491 VGND VPWR sky130_fd_sc_hd__tapvpwrvgnd_1
X_1725_ clknet_leaf_23_clock _0068_ VGND VGND VPWR VPWR scratch\[2\]\[24\] sky130_fd_sc_hd__dfxtp_1
X_1587_ net279 net110 _0519_ VGND VGND VPWR VPWR _0252_ sky130_fd_sc_hd__a21o_1
Xhold125 scratch\[2\]\[23\] VGND VGND VPWR VPWR net401 sky130_fd_sc_hd__dlygate4sd3_1
Xhold158 scratch\[2\]\[22\] VGND VGND VPWR VPWR net434 sky130_fd_sc_hd__dlygate4sd3_1
Xhold103 scratch\[2\]\[0\] VGND VGND VPWR VPWR net379 sky130_fd_sc_hd__dlygate4sd3_1
Xhold114 scratch\[2\]\[1\] VGND VGND VPWR VPWR net390 sky130_fd_sc_hd__dlygate4sd3_1
Xhold136 scratch\[2\]\[25\] VGND VGND VPWR VPWR net412 sky130_fd_sc_hd__dlygate4sd3_1
Xhold147 scratch\[3\]\[31\] VGND VGND VPWR VPWR net423 sky130_fd_sc_hd__dlygate4sd3_1
X_1656_ net46 _0574_ net137 VGND VGND VPWR VPWR _0575_ sky130_fd_sc_hd__mux2_1
XFILLER_22_452 VGND VGND VPWR VPWR sky130_fd_sc_hd__fill_1
XFILLER_14_419 VGND VGND VPWR VPWR sky130_fd_sc_hd__fill_1
XFILLER_72_363 VGND VGND VPWR VPWR sky130_fd_sc_hd__fill_1
XFILLER_57_393 VPWR VGND VPWR VGND sky130_ef_sc_hd__decap_12
XFILLER_57_360 VPWR VGND VPWR VGND sky130_ef_sc_hd__decap_12
XTAP_TAPCELL_ROW_47_539 VGND VPWR sky130_fd_sc_hd__tapvpwrvgnd_1
XTAP_TAPCELL_ROW_4_194 VGND VPWR sky130_fd_sc_hd__tapvpwrvgnd_1
XFILLER_17_246 VGND VGND VPWR VPWR sky130_fd_sc_hd__decap_8
XFILLER_17_279 VGND VGND VPWR VPWR sky130_fd_sc_hd__fill_1
XTAP_TAPCELL_ROW_30_406 VGND VPWR sky130_fd_sc_hd__tapvpwrvgnd_1
X_1441_ _0428_ VGND VGND VPWR VPWR _0429_ sky130_fd_sc_hd__inv_2
X_1510_ net194 _0456_ _0457_ VGND VGND VPWR VPWR _0458_ sky130_fd_sc_hd__and3_1
XFILLER_4_65 VPWR VGND VPWR VGND sky130_ef_sc_hd__decap_12
XFILLER_67_113 VPWR VGND VPWR VGND sky130_ef_sc_hd__decap_12
X_1372_ _0358_ _0375_ _0376_ VGND VGND VPWR VPWR _0377_ sky130_fd_sc_hd__nor3_1
X_1708_ clknet_leaf_18_clock _0051_ VGND VGND VPWR VPWR scratch\[5\]\[18\] sky130_fd_sc_hd__dfxtp_1
XFILLER_2_109 VPWR VGND VPWR VGND sky130_ef_sc_hd__decap_12
XFILLER_48_27 VGND VGND VPWR VPWR sky130_fd_sc_hd__fill_1
X_1639_ scratch\[3\]\[28\] scratch\[2\]\[28\] VGND VGND VPWR VPWR _0561_ sky130_fd_sc_hd__or2_1
XFILLER_73_149 VPWR VGND VPWR VGND sky130_ef_sc_hd__decap_12
XFILLER_73_105 VGND VGND VPWR VPWR sky130_fd_sc_hd__decap_6
XFILLER_64_15 VPWR VGND VPWR VGND sky130_ef_sc_hd__decap_12
XTAP_TAPCELL_ROW_1_175 VGND VPWR sky130_fd_sc_hd__tapvpwrvgnd_1
XFILLER_22_293 VGND VGND VPWR VPWR sky130_fd_sc_hd__fill_1
XFILLER_10_433 VPWR VGND VPWR VGND sky130_ef_sc_hd__decap_12
XFILLER_64_149 VPWR VGND VPWR VGND sky130_ef_sc_hd__decap_12
XFILLER_64_138 VGND VGND VPWR VPWR sky130_fd_sc_hd__fill_2
XFILLER_49_113 VGND VGND VPWR VPWR sky130_fd_sc_hd__decap_3
XFILLER_60_344 VGND VGND VPWR VPWR sky130_fd_sc_hd__decap_8
XFILLER_54_92 VGND VGND VPWR VPWR sky130_fd_sc_hd__decap_4
X_0941_ scratch\[4\]\[16\] net228 net219 scratch\[5\]\[16\] net233 VGND VGND VPWR
+ VPWR _0687_ sky130_fd_sc_hd__a221o_1
Xclkload23 clknet_leaf_11_clock VGND VGND VPWR VPWR clkload23/Y sky130_fd_sc_hd__clkinv_2
Xclkload12 clknet_leaf_5_clock VGND VGND VPWR VPWR clkload12/Y sky130_fd_sc_hd__clkinvlp_4
X_0872_ scratch\[4\]\[5\] net223 net214 scratch\[5\]\[5\] net232 VGND VGND VPWR VPWR
+ _0629_ sky130_fd_sc_hd__a221o_1
XFILLER_68_433 VPWR VGND VPWR VGND sky130_ef_sc_hd__decap_12
X_1424_ net204 _0395_ _0415_ VGND VGND VPWR VPWR _0416_ sky130_fd_sc_hd__and3_1
X_1355_ net48 net154 net117 _0364_ VGND VGND VPWR VPWR _0175_ sky130_fd_sc_hd__a22o_1
XTAP_TAPCELL_ROW_66_689 VGND VPWR sky130_fd_sc_hd__tapvpwrvgnd_1
X_1286_ net34 net167 _0321_ VGND VGND VPWR VPWR _0149_ sky130_fd_sc_hd__a21bo_1
XFILLER_51_311 VPWR VGND VPWR VGND sky130_ef_sc_hd__decap_12
XFILLER_18_19 VGND VGND VPWR VPWR sky130_fd_sc_hd__decap_8
Xclkbuf_leaf_8_clock clknet_2_1__leaf_clock VGND VGND VPWR VPWR clknet_leaf_8_clock
+ sky130_fd_sc_hd__clkbuf_8
XFILLER_51_399 VGND VGND VPWR VPWR sky130_fd_sc_hd__decap_6
Xclkload6 clknet_leaf_27_clock VGND VGND VPWR VPWR clkload6/X sky130_fd_sc_hd__clkbuf_4
XFILLER_59_15 VPWR VGND VPWR VGND sky130_ef_sc_hd__decap_12
XFILLER_3_429 VPWR VGND VPWR VGND sky130_ef_sc_hd__decap_12
XFILLER_75_69 VPWR VGND VPWR VGND sky130_ef_sc_hd__decap_12
XTAP_TAPCELL_ROW_57_623 VGND VPWR sky130_fd_sc_hd__tapvpwrvgnd_1
XFILLER_46_127 VPWR VGND VPWR VGND sky130_ef_sc_hd__decap_12
Xfanout232 net235 VGND VGND VPWR VPWR net232 sky130_fd_sc_hd__buf_2
Xfanout265 net267 VGND VGND VPWR VPWR net265 sky130_fd_sc_hd__clkbuf_4
Xfanout221 _0588_ VGND VGND VPWR VPWR net221 sky130_fd_sc_hd__clkbuf_2
Xfanout276 net12 VGND VGND VPWR VPWR net276 sky130_fd_sc_hd__clkbuf_2
XTAP_TAPCELL_ROW_6_212 VGND VPWR sky130_fd_sc_hd__tapvpwrvgnd_1
Xfanout243 net247 VGND VGND VPWR VPWR net243 sky130_fd_sc_hd__clkbuf_2
Xfanout210 _0594_ VGND VGND VPWR VPWR net210 sky130_fd_sc_hd__clkbuf_4
Xfanout254 net257 VGND VGND VPWR VPWR net254 sky130_fd_sc_hd__buf_2
XFILLER_42_344 VPWR VGND VPWR VGND sky130_ef_sc_hd__decap_12
XFILLER_6_245 VGND VGND VPWR VPWR sky130_fd_sc_hd__decap_6
XTAP_TAPCELL_ROW_12_258 VGND VPWR sky130_fd_sc_hd__tapvpwrvgnd_1
XFILLER_6_289 VPWR VGND VPWR VGND sky130_ef_sc_hd__decap_12
XFILLER_65_447 VGND VGND VPWR VPWR sky130_fd_sc_hd__fill_1
X_1071_ net30 net191 net134 net315 VGND VGND VPWR VPWR _0018_ sky130_fd_sc_hd__a22o_1
X_1140_ net275 net194 net179 net44 VGND VGND VPWR VPWR _0793_ sky130_fd_sc_hd__a22o_1
XFILLER_1_55 VGND VGND VPWR VPWR sky130_fd_sc_hd__fill_1
XFILLER_18_363 VGND VGND VPWR VPWR sky130_fd_sc_hd__fill_1
XFILLER_60_141 VGND VGND VPWR VPWR sky130_fd_sc_hd__decap_3
X_0924_ net256 _0671_ _0672_ VGND VGND VPWR VPWR _0673_ sky130_fd_sc_hd__a21o_1
XTAP_TAPCELL_ROW_28_391 VGND VPWR sky130_fd_sc_hd__tapvpwrvgnd_1
X_0855_ scratch\[2\]\[3\] scratch\[3\]\[3\] net263 VGND VGND VPWR VPWR _0614_ sky130_fd_sc_hd__mux2_1
Xhold18 scratch\[1\]\[21\] VGND VGND VPWR VPWR net294 sky130_fd_sc_hd__dlygate4sd3_1
X_1407_ net150 _0401_ scratch\[0\]\[18\] VGND VGND VPWR VPWR _0403_ sky130_fd_sc_hd__a21oi_1
Xhold29 scratch\[1\]\[13\] VGND VGND VPWR VPWR net305 sky130_fd_sc_hd__dlygate4sd3_1
XFILLER_28_105 VGND VGND VPWR VPWR sky130_fd_sc_hd__fill_2
X_1338_ scratch\[0\]\[0\] scratch\[0\]\[1\] VGND VGND VPWR VPWR _0351_ sky130_fd_sc_hd__nand2_1
XFILLER_71_417 VPWR VGND VPWR VGND sky130_ef_sc_hd__decap_12
X_1269_ net245 net166 scratch\[7\]\[12\] VGND VGND VPWR VPWR _0313_ sky130_fd_sc_hd__or3b_1
XFILLER_51_163 VGND VGND VPWR VPWR sky130_fd_sc_hd__decap_4
XFILLER_36_160 VGND VGND VPWR VPWR sky130_fd_sc_hd__decap_3
XFILLER_24_377 VPWR VGND VPWR VGND sky130_ef_sc_hd__decap_12
XFILLER_24_333 VGND VGND VPWR VPWR sky130_fd_sc_hd__decap_4
XFILLER_61_27 VPWR VGND VPWR VGND sky130_ef_sc_hd__decap_12
XFILLER_3_237 VPWR VGND VPWR VGND sky130_ef_sc_hd__decap_12
XFILLER_10_53 VPWR VGND VPWR VGND sky130_ef_sc_hd__decap_12
XFILLER_74_277 VPWR VGND VPWR VGND sky130_ef_sc_hd__decap_12
XFILLER_74_233 VPWR VGND VPWR VGND sky130_ef_sc_hd__decap_12
XFILLER_62_417 VGND VGND VPWR VPWR sky130_fd_sc_hd__decap_3
XFILLER_47_436 VGND VGND VPWR VPWR sky130_fd_sc_hd__fill_1
XFILLER_19_149 VPWR VGND VPWR VGND sky130_ef_sc_hd__decap_12
XFILLER_42_130 VGND VGND VPWR VPWR sky130_fd_sc_hd__decap_8
XTAP_TAPCELL_ROW_25_361 VGND VPWR sky130_fd_sc_hd__tapvpwrvgnd_1
XFILLER_51_60 VPWR VGND VPWR VGND sky130_ef_sc_hd__decap_12
XTAP_TAPCELL_ROW_68_707 VGND VPWR sky130_fd_sc_hd__tapvpwrvgnd_1
XFILLER_65_211 VPWR VGND VPWR VGND sky130_ef_sc_hd__decap_12
XFILLER_38_425 VGND VGND VPWR VPWR sky130_fd_sc_hd__fill_1
XFILLER_18_3 VGND VGND VPWR VPWR sky130_fd_sc_hd__decap_4
XFILLER_65_244 VPWR VGND VPWR VGND sky130_ef_sc_hd__decap_12
X_1123_ net274 _0578_ _0777_ net12 VGND VGND VPWR VPWR _0789_ sky130_fd_sc_hd__and4b_1
X_1054_ net22 net190 net133 net313 VGND VGND VPWR VPWR _0001_ sky130_fd_sc_hd__a22o_1
X_0907_ scratch\[2\]\[11\] scratch\[3\]\[11\] net271 VGND VGND VPWR VPWR _0658_ sky130_fd_sc_hd__mux2_1
X_1887_ clknet_leaf_19_clock _0229_ VGND VGND VPWR VPWR scratch\[3\]\[26\] sky130_fd_sc_hd__dfxtp_1
Xclkbuf_leaf_11_clock clknet_2_3__leaf_clock VGND VGND VPWR VPWR clknet_leaf_11_clock
+ sky130_fd_sc_hd__clkbuf_8
XFILLER_0_229 VGND VGND VPWR VPWR sky130_fd_sc_hd__fill_1
X_0838_ net264 net254 _0592_ VGND VGND VPWR VPWR _0600_ sky130_fd_sc_hd__or3_1
XFILLER_56_277 VGND VGND VPWR VPWR sky130_fd_sc_hd__decap_4
XTAP_TAPCELL_ROW_39_475 VGND VPWR sky130_fd_sc_hd__tapvpwrvgnd_1
XFILLER_29_436 VGND VGND VPWR VPWR sky130_fd_sc_hd__decap_4
Xclkbuf_leaf_26_clock clknet_2_0__leaf_clock VGND VGND VPWR VPWR clknet_leaf_26_clock
+ sky130_fd_sc_hd__clkbuf_8
XFILLER_72_15 VPWR VGND VPWR VGND sky130_ef_sc_hd__decap_12
XFILLER_71_225 VPWR VGND VPWR VGND sky130_ef_sc_hd__decap_12
XFILLER_24_141 VPWR VGND VPWR VGND sky130_ef_sc_hd__decap_12
XTAP_TAPCELL_ROW_22_342 VGND VPWR sky130_fd_sc_hd__tapvpwrvgnd_1
XFILLER_20_380 VPWR VGND VPWR VGND sky130_ef_sc_hd__decap_12
XFILLER_21_96 VPWR VGND VPWR VGND sky130_ef_sc_hd__decap_12
XFILLER_46_82 VGND VGND VPWR VPWR sky130_fd_sc_hd__fill_2
XFILLER_15_141 VGND VGND VPWR VPWR sky130_fd_sc_hd__fill_2
X_1741_ clknet_leaf_5_clock _0084_ VGND VGND VPWR VPWR scratch\[2\]\[8\] sky130_fd_sc_hd__dfxtp_1
XFILLER_30_166 VGND VGND VPWR VPWR sky130_fd_sc_hd__decap_6
XFILLER_7_54 VGND VGND VPWR VPWR sky130_fd_sc_hd__fill_2
XFILLER_11_391 VGND VGND VPWR VPWR sky130_fd_sc_hd__fill_1
X_1810_ clknet_leaf_21_clock _0153_ VGND VGND VPWR VPWR scratch\[7\]\[24\] sky130_fd_sc_hd__dfxtp_1
X_1672_ clknet_leaf_8_clock _0015_ VGND VGND VPWR VPWR scratch\[4\]\[14\] sky130_fd_sc_hd__dfxtp_1
XFILLER_7_373 VPWR VGND VPWR VGND sky130_ef_sc_hd__decap_12
X_1106_ net29 net186 net129 net319 VGND VGND VPWR VPWR _0049_ sky130_fd_sc_hd__a22o_1
X_1037_ cycle_count\[2\] net236 _0583_ _0766_ VGND VGND VPWR VPWR _0767_ sky130_fd_sc_hd__or4_1
XFILLER_21_166 VGND VGND VPWR VPWR sky130_fd_sc_hd__fill_2
XFILLER_21_177 VGND VGND VPWR VPWR sky130_fd_sc_hd__fill_2
XFILLER_67_15 VPWR VGND VPWR VGND sky130_ef_sc_hd__decap_12
XFILLER_69_391 VGND VGND VPWR VPWR sky130_fd_sc_hd__fill_1
XFILLER_29_233 VGND VGND VPWR VPWR sky130_fd_sc_hd__fill_2
XTAP_TAPCELL_ROW_70_724 VGND VPWR sky130_fd_sc_hd__tapvpwrvgnd_1
XFILLER_32_73 VGND VGND VPWR VPWR sky130_fd_sc_hd__decap_8
XFILLER_32_62 VGND VGND VPWR VPWR sky130_fd_sc_hd__fill_1
XPHY_EDGE_ROW_11_Right_11 VGND VGND VPWR VPWR sky130_fd_sc_hd__decap_3
XFILLER_12_122 VGND VGND VPWR VPWR sky130_fd_sc_hd__fill_2
XFILLER_16_85 VGND VGND VPWR VPWR sky130_fd_sc_hd__decap_3
XFILLER_4_365 VPWR VGND VPWR VGND sky130_ef_sc_hd__decap_12
XFILLER_4_321 VPWR VGND VPWR VGND sky130_ef_sc_hd__decap_12
XPHY_EDGE_ROW_20_Right_20 VGND VGND VPWR VPWR sky130_fd_sc_hd__decap_3
XFILLER_57_92 VGND VGND VPWR VPWR sky130_fd_sc_hd__decap_3
XFILLER_57_70 VGND VGND VPWR VPWR sky130_fd_sc_hd__fill_2
XFILLER_50_217 VGND VGND VPWR VPWR sky130_fd_sc_hd__decap_8
XTAP_TAPCELL_ROW_33_426 VGND VPWR sky130_fd_sc_hd__tapvpwrvgnd_1
Xhold126 scratch\[3\]\[17\] VGND VGND VPWR VPWR net402 sky130_fd_sc_hd__dlygate4sd3_1
X_1724_ clknet_leaf_15_clock _0067_ VGND VGND VPWR VPWR scratch\[2\]\[23\] sky130_fd_sc_hd__dfxtp_1
XTAP_TAPCELL_ROW_41_492 VGND VPWR sky130_fd_sc_hd__tapvpwrvgnd_1
Xhold104 scratch\[2\]\[15\] VGND VGND VPWR VPWR net380 sky130_fd_sc_hd__dlygate4sd3_1
Xhold115 scratch\[3\]\[25\] VGND VGND VPWR VPWR net391 sky130_fd_sc_hd__dlygate4sd3_1
XFILLER_7_181 VPWR VGND VPWR VGND sky130_ef_sc_hd__decap_12
Xhold148 scratch\[3\]\[19\] VGND VGND VPWR VPWR net424 sky130_fd_sc_hd__dlygate4sd3_1
XFILLER_58_306 VGND VGND VPWR VPWR sky130_fd_sc_hd__fill_2
X_1586_ net30 _0518_ net140 VGND VGND VPWR VPWR _0519_ sky130_fd_sc_hd__mux2_1
Xhold159 scratch\[3\]\[8\] VGND VGND VPWR VPWR net435 sky130_fd_sc_hd__dlygate4sd3_1
Xhold137 scratch\[2\]\[24\] VGND VGND VPWR VPWR net413 sky130_fd_sc_hd__dlygate4sd3_1
X_1655_ net195 _0572_ _0573_ VGND VGND VPWR VPWR _0574_ sky130_fd_sc_hd__and3_1
XFILLER_66_372 VPWR VGND VPWR VGND sky130_ef_sc_hd__decap_12
XFILLER_26_214 VGND VGND VPWR VPWR sky130_fd_sc_hd__fill_1
XFILLER_34_291 VGND VGND VPWR VPWR sky130_fd_sc_hd__decap_8
XFILLER_64_309 VGND VGND VPWR VPWR sky130_fd_sc_hd__decap_4
XFILLER_57_372 VGND VGND VPWR VPWR sky130_fd_sc_hd__decap_8
XFILLER_1_335 VGND VGND VPWR VPWR sky130_fd_sc_hd__fill_1
XTAP_TAPCELL_ROW_4_195 VGND VPWR sky130_fd_sc_hd__tapvpwrvgnd_1
XFILLER_17_225 VGND VGND VPWR VPWR sky130_fd_sc_hd__fill_1
XFILLER_40_283 VGND VGND VPWR VPWR sky130_fd_sc_hd__decap_8
XFILLER_40_272 VGND VGND VPWR VPWR sky130_fd_sc_hd__decap_3
XFILLER_40_250 VGND VGND VPWR VPWR sky130_fd_sc_hd__fill_2
XTAP_TAPCELL_ROW_30_407 VGND VPWR sky130_fd_sc_hd__tapvpwrvgnd_1
X_1371_ scratch\[0\]\[8\] scratch\[0\]\[9\] net148 net204 VGND VGND VPWR VPWR _0376_
+ sky130_fd_sc_hd__and4_1
X_1440_ scratch\[0\]\[24\] scratch\[0\]\[25\] scratch\[0\]\[26\] VGND VGND VPWR VPWR
+ _0428_ sky130_fd_sc_hd__and3_1
XFILLER_4_195 VGND VGND VPWR VPWR sky130_fd_sc_hd__fill_1
XFILLER_4_77 VGND VGND VPWR VPWR sky130_fd_sc_hd__decap_6
XFILLER_75_191 VGND VGND VPWR VPWR sky130_fd_sc_hd__decap_4
XFILLER_67_125 VPWR VGND VPWR VGND sky130_ef_sc_hd__decap_12
XFILLER_63_353 VGND VGND VPWR VPWR sky130_fd_sc_hd__fill_1
XFILLER_23_217 VGND VGND VPWR VPWR sky130_fd_sc_hd__decap_6
XFILLER_23_206 VGND VGND VPWR VPWR sky130_fd_sc_hd__decap_3
X_1707_ clknet_leaf_10_clock _0050_ VGND VGND VPWR VPWR scratch\[5\]\[17\] sky130_fd_sc_hd__dfxtp_1
X_1638_ scratch\[3\]\[28\] scratch\[2\]\[28\] VGND VGND VPWR VPWR _0560_ sky130_fd_sc_hd__nand2_1
X_1569_ scratch\[3\]\[14\] scratch\[2\]\[14\] VGND VGND VPWR VPWR _0505_ sky130_fd_sc_hd__or2_1
XFILLER_58_136 VGND VGND VPWR VPWR sky130_fd_sc_hd__decap_4
XFILLER_58_114 VGND VGND VPWR VPWR sky130_fd_sc_hd__decap_4
XFILLER_46_309 VPWR VGND VPWR VGND sky130_ef_sc_hd__decap_12
XFILLER_64_27 VGND VGND VPWR VPWR sky130_fd_sc_hd__fill_1
XFILLER_14_217 VGND VGND VPWR VPWR sky130_fd_sc_hd__fill_2
XTAP_TAPCELL_ROW_52_576 VGND VPWR sky130_fd_sc_hd__tapvpwrvgnd_1
XFILLER_10_401 VPWR VGND VPWR VGND sky130_ef_sc_hd__decap_12
XFILLER_10_445 VGND VGND VPWR VPWR sky130_fd_sc_hd__decap_4
XFILLER_13_42 VPWR VGND VPWR VGND sky130_ef_sc_hd__decap_12
XTAP_TAPCELL_ROW_9_232 VGND VPWR sky130_fd_sc_hd__tapvpwrvgnd_1
XFILLER_49_169 VGND VGND VPWR VPWR sky130_fd_sc_hd__fill_1
XFILLER_38_83 VGND VGND VPWR VPWR sky130_fd_sc_hd__fill_1
X_0940_ net261 _0685_ VGND VGND VPWR VPWR _0686_ sky130_fd_sc_hd__and2_1
XTAP_TAPCELL_ROW_43_510 VGND VPWR sky130_fd_sc_hd__tapvpwrvgnd_1
XFILLER_20_209 VPWR VGND VPWR VGND sky130_ef_sc_hd__decap_12
Xclkload24 clknet_leaf_12_clock VGND VGND VPWR VPWR clkload24/Y sky130_fd_sc_hd__clkinv_2
Xclkload13 clknet_leaf_6_clock VGND VGND VPWR VPWR clkload13/Y sky130_fd_sc_hd__inv_6
X_0871_ net255 _0627_ VGND VGND VPWR VPWR _0628_ sky130_fd_sc_hd__and2_1
XFILLER_9_276 VGND VGND VPWR VPWR sky130_fd_sc_hd__decap_4
XFILLER_9_298 VPWR VGND VPWR VGND sky130_ef_sc_hd__decap_12
XFILLER_68_445 VGND VGND VPWR VPWR sky130_fd_sc_hd__decap_8
XFILLER_68_401 VPWR VGND VPWR VGND sky130_ef_sc_hd__decap_12
X_1285_ net246 net167 scratch\[7\]\[20\] VGND VGND VPWR VPWR _0321_ sky130_fd_sc_hd__or3b_1
X_1354_ _0362_ _0363_ VGND VGND VPWR VPWR _0364_ sky130_fd_sc_hd__nor2_1
X_1423_ scratch\[0\]\[22\] _0400_ _0412_ VGND VGND VPWR VPWR _0415_ sky130_fd_sc_hd__and3_1
XFILLER_70_109 VPWR VGND VPWR VGND sky130_ef_sc_hd__decap_12
XFILLER_63_194 VGND VGND VPWR VPWR sky130_fd_sc_hd__fill_2
XFILLER_36_397 VPWR VGND VPWR VGND sky130_ef_sc_hd__decap_12
XFILLER_50_29 VPWR VGND VPWR VGND sky130_ef_sc_hd__decap_12
Xclkload7 clknet_leaf_28_clock VGND VGND VPWR VPWR clkload7/X sky130_fd_sc_hd__clkbuf_8
XFILLER_59_401 VPWR VGND VPWR VGND sky130_ef_sc_hd__decap_12
XFILLER_59_27 VPWR VGND VPWR VGND sky130_ef_sc_hd__decap_12
Xfanout222 net225 VGND VGND VPWR VPWR net222 sky130_fd_sc_hd__buf_2
Xfanout200 net203 VGND VGND VPWR VPWR net200 sky130_fd_sc_hd__dlymetal6s2s_1
Xfanout211 net68 VGND VGND VPWR VPWR net211 sky130_fd_sc_hd__clkbuf_2
XTAP_TAPCELL_ROW_6_213 VGND VPWR sky130_fd_sc_hd__tapvpwrvgnd_1
XFILLER_75_15 VPWR VGND VPWR VGND sky130_ef_sc_hd__decap_12
XFILLER_59_445 VGND VGND VPWR VPWR sky130_fd_sc_hd__decap_3
XFILLER_46_139 VGND VGND VPWR VPWR sky130_fd_sc_hd__fill_1
Xfanout233 net234 VGND VGND VPWR VPWR net233 sky130_fd_sc_hd__buf_2
Xfanout266 net267 VGND VGND VPWR VPWR net266 sky130_fd_sc_hd__buf_2
Xfanout255 net256 VGND VGND VPWR VPWR net255 sky130_fd_sc_hd__buf_2
XFILLER_27_320 VGND VGND VPWR VPWR sky130_fd_sc_hd__decap_4
Xfanout244 net247 VGND VGND VPWR VPWR net244 sky130_fd_sc_hd__clkbuf_2
XFILLER_19_309 VGND VGND VPWR VPWR sky130_fd_sc_hd__decap_4
XFILLER_42_356 VGND VGND VPWR VPWR sky130_fd_sc_hd__decap_8
XFILLER_27_386 VGND VGND VPWR VPWR sky130_fd_sc_hd__decap_6
XFILLER_10_253 VPWR VGND VPWR VGND sky130_ef_sc_hd__decap_12
XTAP_TAPCELL_ROW_12_259 VGND VPWR sky130_fd_sc_hd__tapvpwrvgnd_1
XFILLER_65_81 VPWR VGND VPWR VGND sky130_ef_sc_hd__decap_12
X_1070_ net29 net191 net134 net333 VGND VGND VPWR VPWR _0017_ sky130_fd_sc_hd__a22o_1
XFILLER_60_197 VGND VGND VPWR VPWR sky130_fd_sc_hd__decap_8
X_0923_ scratch\[4\]\[13\] net224 net215 scratch\[5\]\[13\] net232 VGND VGND VPWR
+ VPWR _0672_ sky130_fd_sc_hd__a221o_1
X_0854_ net206 _0611_ _0613_ _0601_ net71 VGND VGND VPWR VPWR net97 sky130_fd_sc_hd__a32o_1
XPHY_EDGE_ROW_49_Right_49 VGND VGND VPWR VPWR sky130_fd_sc_hd__decap_3
X_1268_ net24 net166 _0312_ VGND VGND VPWR VPWR _0140_ sky130_fd_sc_hd__a21bo_1
XFILLER_68_253 VPWR VGND VPWR VGND sky130_ef_sc_hd__decap_12
XPHY_EDGE_ROW_58_Right_58 VGND VGND VPWR VPWR sky130_fd_sc_hd__decap_3
X_1406_ net30 net156 net119 _0402_ VGND VGND VPWR VPWR _0188_ sky130_fd_sc_hd__a22o_1
Xhold19 scratch\[1\]\[6\] VGND VGND VPWR VPWR net295 sky130_fd_sc_hd__dlygate4sd3_1
X_1337_ net22 _0347_ _0350_ VGND VGND VPWR VPWR _0171_ sky130_fd_sc_hd__a21o_1
XFILLER_71_429 VPWR VGND VPWR VGND sky130_ef_sc_hd__decap_12
X_1199_ net53 net172 _0277_ VGND VGND VPWR VPWR _0106_ sky130_fd_sc_hd__a21bo_1
XTAP_TAPCELL_ROW_62_660 VGND VPWR sky130_fd_sc_hd__tapvpwrvgnd_1
XFILLER_61_39 VGND VGND VPWR VPWR sky130_fd_sc_hd__decap_8
XFILLER_24_389 VPWR VGND VPWR VGND sky130_ef_sc_hd__decap_12
XPHY_EDGE_ROW_67_Right_67 VGND VGND VPWR VPWR sky130_fd_sc_hd__decap_3
XFILLER_3_205 VPWR VGND VPWR VGND sky130_ef_sc_hd__decap_12
XFILLER_3_249 VPWR VGND VPWR VGND sky130_ef_sc_hd__decap_12
XFILLER_10_65 VPWR VGND VPWR VGND sky130_ef_sc_hd__decap_12
XFILLER_74_289 VPWR VGND VPWR VGND sky130_ef_sc_hd__decap_12
XFILLER_74_245 VGND VGND VPWR VPWR sky130_fd_sc_hd__decap_6
XFILLER_42_120 VGND VGND VPWR VPWR sky130_fd_sc_hd__decap_3
XFILLER_51_72 VGND VGND VPWR VPWR sky130_fd_sc_hd__decap_3
XFILLER_42_197 VGND VGND VPWR VPWR sky130_fd_sc_hd__decap_8
XFILLER_30_304 VGND VGND VPWR VPWR sky130_fd_sc_hd__decap_4
XTAP_TAPCELL_ROW_25_362 VGND VPWR sky130_fd_sc_hd__tapvpwrvgnd_1
XPHY_EDGE_ROW_69_Left_145 VGND VGND VPWR VPWR sky130_fd_sc_hd__decap_3
XTAP_TAPCELL_ROW_68_708 VGND VPWR sky130_fd_sc_hd__tapvpwrvgnd_1
Xclkbuf_leaf_7_clock clknet_2_1__leaf_clock VGND VGND VPWR VPWR clknet_leaf_7_clock
+ sky130_fd_sc_hd__clkbuf_8
XFILLER_65_256 VPWR VGND VPWR VGND sky130_ef_sc_hd__decap_12
XFILLER_65_223 VGND VGND VPWR VPWR sky130_fd_sc_hd__fill_1
X_1122_ cycle_count\[3\] _0577_ _0582_ net236 VGND VGND VPWR VPWR _0788_ sky130_fd_sc_hd__a31o_2
XFILLER_32_6 VPWR VGND VPWR VGND sky130_ef_sc_hd__decap_12
X_1053_ net238 net190 VGND VGND VPWR VPWR _0783_ sky130_fd_sc_hd__nor2_1
XFILLER_25_109 VGND VGND VPWR VPWR sky130_fd_sc_hd__decap_3
X_0906_ net248 _0654_ _0656_ _0657_ net207 VGND VGND VPWR VPWR net76 sky130_fd_sc_hd__o221a_1
X_1886_ clknet_leaf_21_clock _0228_ VGND VGND VPWR VPWR scratch\[3\]\[25\] sky130_fd_sc_hd__dfxtp_1
X_0837_ _0593_ net249 net59 VGND VGND VPWR VPWR _0599_ sky130_fd_sc_hd__or3b_1
XFILLER_71_237 VPWR VGND VPWR VGND sky130_ef_sc_hd__decap_12
XFILLER_56_289 VGND VGND VPWR VPWR sky130_fd_sc_hd__decap_6
XFILLER_56_245 VGND VGND VPWR VPWR sky130_fd_sc_hd__decap_6
XFILLER_56_201 VGND VGND VPWR VPWR sky130_fd_sc_hd__fill_1
XFILLER_44_418 VGND VGND VPWR VPWR sky130_fd_sc_hd__fill_2
XTAP_TAPCELL_ROW_39_476 VGND VPWR sky130_fd_sc_hd__tapvpwrvgnd_1
XFILLER_29_404 VPWR VGND VPWR VGND sky130_ef_sc_hd__decap_12
XFILLER_72_27 VGND VGND VPWR VPWR sky130_fd_sc_hd__fill_1
XFILLER_24_153 VPWR VGND VPWR VGND sky130_ef_sc_hd__decap_12
XTAP_TAPCELL_ROW_22_343 VGND VPWR sky130_fd_sc_hd__tapvpwrvgnd_1
XFILLER_20_392 VGND VGND VPWR VPWR sky130_fd_sc_hd__fill_2
XTAP_TAPCELL_ROW_73_744 VGND VPWR sky130_fd_sc_hd__tapvpwrvgnd_1
XFILLER_62_93 VGND VGND VPWR VPWR sky130_fd_sc_hd__decap_6
X_1740_ clknet_leaf_5_clock _0083_ VGND VGND VPWR VPWR scratch\[2\]\[7\] sky130_fd_sc_hd__dfxtp_1
X_1671_ clknet_leaf_8_clock _0014_ VGND VGND VPWR VPWR scratch\[4\]\[13\] sky130_fd_sc_hd__dfxtp_1
XFILLER_30_134 VGND VGND VPWR VPWR sky130_fd_sc_hd__fill_1
XFILLER_30_3 VGND VGND VPWR VPWR sky130_fd_sc_hd__fill_1
XFILLER_7_385 VGND VGND VPWR VPWR sky130_fd_sc_hd__decap_6
X_1105_ net28 net187 net130 net327 VGND VGND VPWR VPWR _0048_ sky130_fd_sc_hd__a22o_1
XFILLER_61_281 VPWR VGND VPWR VGND sky130_ef_sc_hd__decap_12
XFILLER_42_19 VGND VGND VPWR VPWR sky130_fd_sc_hd__decap_8
X_1036_ net275 net1 net276 VGND VGND VPWR VPWR _0766_ sky130_fd_sc_hd__or3b_1
X_1869_ clknet_leaf_8_clock _0211_ VGND VGND VPWR VPWR scratch\[3\]\[8\] sky130_fd_sc_hd__dfxtp_1
XFILLER_67_27 VPWR VGND VPWR VGND sky130_ef_sc_hd__decap_12
XFILLER_29_223 VGND VGND VPWR VPWR sky130_fd_sc_hd__fill_1
XTAP_TAPCELL_ROW_70_725 VGND VPWR sky130_fd_sc_hd__tapvpwrvgnd_1
XFILLER_44_226 VGND VGND VPWR VPWR sky130_fd_sc_hd__decap_6
XFILLER_40_432 VPWR VGND VPWR VGND sky130_ef_sc_hd__decap_12
XFILLER_40_421 VGND VGND VPWR VPWR sky130_fd_sc_hd__decap_3
XFILLER_12_145 VGND VGND VPWR VPWR sky130_fd_sc_hd__fill_1
XFILLER_16_97 VGND VGND VPWR VPWR sky130_fd_sc_hd__fill_1
XFILLER_4_377 VPWR VGND VPWR VGND sky130_ef_sc_hd__decap_12
XFILLER_4_333 VPWR VGND VPWR VGND sky130_ef_sc_hd__decap_12
XFILLER_73_81 VPWR VGND VPWR VGND sky130_ef_sc_hd__decap_12
Xclkbuf_leaf_10_clock clknet_2_3__leaf_clock VGND VGND VPWR VPWR clknet_leaf_10_clock
+ sky130_fd_sc_hd__clkbuf_8
XTAP_TAPCELL_ROW_33_427 VGND VPWR sky130_fd_sc_hd__tapvpwrvgnd_1
Xhold105 scratch\[2\]\[16\] VGND VGND VPWR VPWR net381 sky130_fd_sc_hd__dlygate4sd3_1
XTAP_TAPCELL_ROW_41_493 VGND VPWR sky130_fd_sc_hd__tapvpwrvgnd_1
Xhold149 scratch\[3\]\[13\] VGND VGND VPWR VPWR net425 sky130_fd_sc_hd__dlygate4sd3_1
X_1723_ clknet_leaf_16_clock _0066_ VGND VGND VPWR VPWR scratch\[2\]\[22\] sky130_fd_sc_hd__dfxtp_1
Xhold138 scratch\[2\]\[26\] VGND VGND VPWR VPWR net414 sky130_fd_sc_hd__dlygate4sd3_1
X_1654_ scratch\[3\]\[31\] scratch\[2\]\[31\] VGND VGND VPWR VPWR _0573_ sky130_fd_sc_hd__or2_1
Xhold116 scratch\[3\]\[24\] VGND VGND VPWR VPWR net392 sky130_fd_sc_hd__dlygate4sd3_1
Xclkbuf_leaf_25_clock clknet_2_0__leaf_clock VGND VGND VPWR VPWR clknet_leaf_25_clock
+ sky130_fd_sc_hd__clkbuf_8
Xhold127 scratch\[3\]\[0\] VGND VGND VPWR VPWR net403 sky130_fd_sc_hd__dlygate4sd3_1
XFILLER_7_193 VPWR VGND VPWR VGND sky130_ef_sc_hd__decap_12
X_1585_ net202 _0516_ _0517_ VGND VGND VPWR VPWR _0518_ sky130_fd_sc_hd__and3_1
XFILLER_58_318 VPWR VGND VPWR VGND sky130_ef_sc_hd__decap_12
XFILLER_66_384 VPWR VGND VPWR VGND sky130_ef_sc_hd__decap_12
XFILLER_53_18 VPWR VGND VPWR VGND sky130_ef_sc_hd__decap_12
XFILLER_41_229 VGND VGND VPWR VPWR sky130_fd_sc_hd__fill_1
X_1019_ scratch\[0\]\[29\] net226 _0751_ VGND VGND VPWR VPWR _0752_ sky130_fd_sc_hd__a21o_1
XFILLER_72_321 VPWR VGND VPWR VGND sky130_ef_sc_hd__decap_12
XFILLER_27_41 VGND VGND VPWR VPWR sky130_fd_sc_hd__decap_4
XTAP_TAPCELL_ROW_4_196 VGND VPWR sky130_fd_sc_hd__tapvpwrvgnd_1
XFILLER_72_365 VPWR VGND VPWR VGND sky130_ef_sc_hd__decap_12
XFILLER_43_62 VGND VGND VPWR VPWR sky130_fd_sc_hd__decap_8
XFILLER_25_292 VGND VGND VPWR VPWR sky130_fd_sc_hd__fill_2
XFILLER_4_141 VPWR VGND VPWR VGND sky130_ef_sc_hd__decap_12
XFILLER_9_447 VGND VGND VPWR VPWR sky130_fd_sc_hd__fill_1
XFILLER_67_137 VPWR VGND VPWR VGND sky130_ef_sc_hd__decap_12
X_1370_ scratch\[0\]\[8\] net147 net204 scratch\[0\]\[9\] VGND VGND VPWR VPWR _0375_
+ sky130_fd_sc_hd__a31oi_1
XFILLER_63_310 VPWR VGND VPWR VGND sky130_ef_sc_hd__decap_12
XFILLER_48_395 VGND VGND VPWR VPWR sky130_fd_sc_hd__decap_8
XFILLER_48_373 VGND VGND VPWR VPWR sky130_fd_sc_hd__decap_3
XTAP_TAPCELL_ROW_46_530 VGND VPWR sky130_fd_sc_hd__tapvpwrvgnd_1
X_1706_ clknet_leaf_9_clock _0049_ VGND VGND VPWR VPWR scratch\[5\]\[16\] sky130_fd_sc_hd__dfxtp_1
X_1637_ net277 net110 _0559_ VGND VGND VPWR VPWR _0262_ sky130_fd_sc_hd__a21o_1
X_1568_ scratch\[3\]\[14\] scratch\[2\]\[14\] VGND VGND VPWR VPWR _0504_ sky130_fd_sc_hd__nand2_1
X_1499_ scratch\[3\]\[0\] scratch\[2\]\[0\] VGND VGND VPWR VPWR _0449_ sky130_fd_sc_hd__or2_1
XTAP_TAPCELL_ROW_52_577 VGND VPWR sky130_fd_sc_hd__tapvpwrvgnd_1
XFILLER_22_251 VGND VGND VPWR VPWR sky130_fd_sc_hd__fill_1
XFILLER_14_229 VPWR VGND VPWR VGND sky130_ef_sc_hd__decap_12
XFILLER_10_413 VGND VGND VPWR VPWR sky130_fd_sc_hd__decap_6
XFILLER_13_54 VGND VGND VPWR VPWR sky130_fd_sc_hd__fill_2
XFILLER_1_111 VGND VGND VPWR VPWR sky130_fd_sc_hd__fill_1
XTAP_TAPCELL_ROW_9_233 VGND VPWR sky130_fd_sc_hd__tapvpwrvgnd_1
XFILLER_57_181 VGND VGND VPWR VPWR sky130_fd_sc_hd__decap_4
XPHY_EDGE_ROW_32_Left_108 VGND VGND VPWR VPWR sky130_fd_sc_hd__decap_3
XFILLER_72_195 VGND VGND VPWR VPWR sky130_fd_sc_hd__fill_1
XFILLER_54_83 VGND VGND VPWR VPWR sky130_fd_sc_hd__fill_1
X_0870_ scratch\[6\]\[5\] scratch\[7\]\[5\] net265 VGND VGND VPWR VPWR _0627_ sky130_fd_sc_hd__mux2_1
XTAP_TAPCELL_ROW_43_511 VGND VPWR sky130_fd_sc_hd__tapvpwrvgnd_1
XPHY_EDGE_ROW_41_Left_117 VGND VGND VPWR VPWR sky130_fd_sc_hd__decap_3
XFILLER_9_233 VGND VGND VPWR VPWR sky130_fd_sc_hd__fill_1
Xclkload14 clknet_leaf_7_clock VGND VGND VPWR VPWR clkload14/Y sky130_fd_sc_hd__inv_6
Xclkload25 clknet_leaf_13_clock VGND VGND VPWR VPWR clkload25/X sky130_fd_sc_hd__clkbuf_4
X_1422_ net35 net156 net119 _0414_ VGND VGND VPWR VPWR _0192_ sky130_fd_sc_hd__a22o_1
XFILLER_68_413 VGND VGND VPWR VPWR sky130_fd_sc_hd__decap_6
X_1284_ net32 net167 _0320_ VGND VGND VPWR VPWR _0148_ sky130_fd_sc_hd__a21bo_1
XPHY_EDGE_ROW_50_Left_126 VGND VGND VPWR VPWR sky130_fd_sc_hd__decap_3
X_1353_ scratch\[0\]\[4\] net147 _0360_ VGND VGND VPWR VPWR _0363_ sky130_fd_sc_hd__and3_1
Xclkload8 clknet_leaf_29_clock VGND VGND VPWR VPWR clkload8/Y sky130_fd_sc_hd__clkinvlp_4
X_0999_ net209 _0732_ _0735_ VGND VGND VPWR VPWR net92 sky130_fd_sc_hd__and3_1
Xfanout201 net203 VGND VGND VPWR VPWR net201 sky130_fd_sc_hd__clkbuf_2
XFILLER_59_413 VPWR VGND VPWR VGND sky130_ef_sc_hd__decap_12
XFILLER_59_39 VGND VGND VPWR VPWR sky130_fd_sc_hd__decap_4
Xfanout245 net247 VGND VGND VPWR VPWR net245 sky130_fd_sc_hd__clkbuf_2
Xfanout256 net257 VGND VGND VPWR VPWR net256 sky130_fd_sc_hd__buf_2
Xfanout223 net225 VGND VGND VPWR VPWR net223 sky130_fd_sc_hd__buf_2
Xfanout212 net68 VGND VGND VPWR VPWR net212 sky130_fd_sc_hd__buf_1
XTAP_TAPCELL_ROW_6_214 VGND VPWR sky130_fd_sc_hd__tapvpwrvgnd_1
Xfanout234 net235 VGND VGND VPWR VPWR net234 sky130_fd_sc_hd__buf_2
XFILLER_75_27 VGND VGND VPWR VPWR sky130_fd_sc_hd__fill_1
Xfanout267 net273 VGND VGND VPWR VPWR net267 sky130_fd_sc_hd__buf_2
XTAP_TAPCELL_ROW_65_680 VGND VPWR sky130_fd_sc_hd__tapvpwrvgnd_1
XFILLER_40_63 VGND VGND VPWR VPWR sky130_fd_sc_hd__decap_4
XFILLER_40_41 VGND VGND VPWR VPWR sky130_fd_sc_hd__decap_3
XFILLER_10_265 VGND VGND VPWR VPWR sky130_fd_sc_hd__decap_4
XFILLER_10_276 VGND VGND VPWR VPWR sky130_fd_sc_hd__decap_8
XFILLER_65_405 VPWR VGND VPWR VGND sky130_ef_sc_hd__decap_12
XFILLER_27_9 VGND VGND VPWR VPWR sky130_fd_sc_hd__decap_3
XFILLER_65_449 VGND VGND VPWR VPWR sky130_fd_sc_hd__decap_4
XFILLER_65_93 VPWR VGND VPWR VGND sky130_ef_sc_hd__decap_12
XFILLER_60_121 VPWR VGND VPWR VGND sky130_ef_sc_hd__decap_12
XFILLER_33_335 VGND VGND VPWR VPWR sky130_fd_sc_hd__fill_1
XFILLER_33_313 VGND VGND VPWR VPWR sky130_fd_sc_hd__fill_1
XFILLER_1_57 VPWR VGND VPWR VGND sky130_ef_sc_hd__decap_12
XFILLER_18_321 VGND VGND VPWR VPWR sky130_fd_sc_hd__fill_1
XFILLER_18_354 VGND VGND VPWR VPWR sky130_fd_sc_hd__fill_1
X_0922_ scratch\[6\]\[13\] scratch\[7\]\[13\] net267 VGND VGND VPWR VPWR _0671_ sky130_fd_sc_hd__mux2_1
X_0853_ net231 _0612_ VGND VGND VPWR VPWR _0613_ sky130_fd_sc_hd__or2_1
X_1405_ net151 _0401_ _0398_ scratch\[0\]\[17\] VGND VGND VPWR VPWR _0402_ sky130_fd_sc_hd__o2bb2a_1
XFILLER_68_276 VGND VGND VPWR VPWR sky130_fd_sc_hd__decap_4
XFILLER_68_265 VGND VGND VPWR VPWR sky130_fd_sc_hd__decap_3
X_1198_ net240 net172 scratch\[6\]\[9\] VGND VGND VPWR VPWR _0277_ sky130_fd_sc_hd__or3b_1
X_1267_ net245 net166 scratch\[7\]\[11\] VGND VGND VPWR VPWR _0312_ sky130_fd_sc_hd__or3b_1
XFILLER_56_449 VGND VGND VPWR VPWR sky130_fd_sc_hd__decap_4
Xinput1 host_input_addr[0] VGND VGND VPWR VPWR net1 sky130_fd_sc_hd__clkbuf_2
X_1336_ net197 _0348_ scratch\[0\]\[0\] VGND VGND VPWR VPWR _0350_ sky130_fd_sc_hd__mux2_1
XFILLER_24_302 VGND VGND VPWR VPWR sky130_fd_sc_hd__decap_6
XTAP_TAPCELL_ROW_62_661 VGND VPWR sky130_fd_sc_hd__tapvpwrvgnd_1
XFILLER_51_187 VGND VGND VPWR VPWR sky130_fd_sc_hd__decap_6
XFILLER_3_217 VGND VGND VPWR VPWR sky130_fd_sc_hd__decap_6
XFILLER_59_210 VPWR VGND VPWR VGND sky130_ef_sc_hd__decap_12
XFILLER_10_77 VGND VGND VPWR VPWR sky130_fd_sc_hd__decap_6
XFILLER_19_31 VPWR VGND VPWR VGND sky130_ef_sc_hd__decap_12
XFILLER_19_107 VGND VGND VPWR VPWR sky130_fd_sc_hd__decap_4
XFILLER_35_63 VGND VGND VPWR VPWR sky130_fd_sc_hd__fill_1
XFILLER_27_140 VPWR VGND VPWR VGND sky130_ef_sc_hd__decap_12
XTAP_TAPCELL_ROW_25_363 VGND VPWR sky130_fd_sc_hd__tapvpwrvgnd_1
XTAP_TAPCELL_ROW_68_709 VGND VPWR sky130_fd_sc_hd__tapvpwrvgnd_1
XFILLER_65_268 VPWR VGND VPWR VGND sky130_ef_sc_hd__decap_12
X_1052_ net276 net274 _0584_ _0772_ _0776_ VGND VGND VPWR VPWR _0782_ sky130_fd_sc_hd__o311a_1
X_1121_ net46 net184 net127 net330 VGND VGND VPWR VPWR _0064_ sky130_fd_sc_hd__a22o_1
XFILLER_61_441 VGND VGND VPWR VPWR sky130_fd_sc_hd__decap_6
XFILLER_18_195 VGND VGND VPWR VPWR sky130_fd_sc_hd__fill_1
X_0905_ scratch\[4\]\[10\] net224 net215 scratch\[5\]\[10\] net232 VGND VGND VPWR
+ VPWR _0657_ sky130_fd_sc_hd__a221o_1
X_1885_ clknet_leaf_21_clock _0227_ VGND VGND VPWR VPWR scratch\[3\]\[24\] sky130_fd_sc_hd__dfxtp_1
X_0836_ _0591_ net206 _0597_ VGND VGND VPWR VPWR _0598_ sky130_fd_sc_hd__and3_1
XFILLER_29_416 VGND VGND VPWR VPWR sky130_fd_sc_hd__fill_2
XFILLER_71_249 VPWR VGND VPWR VGND sky130_ef_sc_hd__decap_12
XFILLER_71_205 VPWR VGND VPWR VGND sky130_ef_sc_hd__decap_12
XTAP_TAPCELL_ROW_39_477 VGND VPWR sky130_fd_sc_hd__tapvpwrvgnd_1
XFILLER_29_449 VGND VGND VPWR VPWR sky130_fd_sc_hd__decap_4
X_1319_ _0339_ net205 _0338_ VGND VGND VPWR VPWR _0164_ sky130_fd_sc_hd__and3b_1
XFILLER_24_165 VPWR VGND VPWR VGND sky130_ef_sc_hd__decap_12
XFILLER_8_309 VPWR VGND VPWR VGND sky130_ef_sc_hd__decap_12
XFILLER_12_305 VGND VGND VPWR VPWR sky130_fd_sc_hd__decap_3
XFILLER_21_65 VGND VGND VPWR VPWR sky130_fd_sc_hd__decap_4
XFILLER_47_279 VGND VGND VPWR VPWR sky130_fd_sc_hd__fill_1
XFILLER_46_40 VPWR VGND VPWR VGND sky130_ef_sc_hd__decap_12
XTAP_TAPCELL_ROW_73_745 VGND VPWR sky130_fd_sc_hd__tapvpwrvgnd_1
XFILLER_46_95 VGND VGND VPWR VPWR sky130_fd_sc_hd__decap_3
XFILLER_46_62 VPWR VGND VPWR VGND sky130_ef_sc_hd__decap_12
XFILLER_43_430 VGND VGND VPWR VPWR sky130_fd_sc_hd__fill_2
XFILLER_15_121 VPWR VGND VPWR VGND sky130_ef_sc_hd__decap_12
XFILLER_62_83 VGND VGND VPWR VPWR sky130_fd_sc_hd__fill_1
X_1670_ clknet_leaf_9_clock _0013_ VGND VGND VPWR VPWR scratch\[4\]\[12\] sky130_fd_sc_hd__dfxtp_1
XFILLER_30_179 VPWR VGND VPWR VGND sky130_ef_sc_hd__decap_12
XFILLER_11_393 VPWR VGND VPWR VGND sky130_ef_sc_hd__decap_12
XFILLER_53_205 VGND VGND VPWR VPWR sky130_fd_sc_hd__decap_3
X_1104_ net27 net188 net128 net371 VGND VGND VPWR VPWR _0047_ sky130_fd_sc_hd__a22o_1
XFILLER_38_279 VGND VGND VPWR VPWR sky130_fd_sc_hd__decap_3
XFILLER_38_224 VGND VGND VPWR VPWR sky130_fd_sc_hd__fill_2
X_1035_ net206 _0762_ _0765_ VGND VGND VPWR VPWR net99 sky130_fd_sc_hd__and3_1
XFILLER_61_293 VPWR VGND VPWR VGND sky130_ef_sc_hd__decap_12
XFILLER_61_271 VGND VGND VPWR VPWR sky130_fd_sc_hd__decap_8
X_1868_ clknet_leaf_5_clock _0210_ VGND VGND VPWR VPWR scratch\[3\]\[7\] sky130_fd_sc_hd__dfxtp_1
X_1799_ clknet_leaf_2_clock _0142_ VGND VGND VPWR VPWR scratch\[7\]\[13\] sky130_fd_sc_hd__dfxtp_1
X_0819_ net211 cycle_count\[1\] cycle_count\[0\] VGND VGND VPWR VPWR _0582_ sky130_fd_sc_hd__and3_1
XFILLER_69_393 VPWR VGND VPWR VGND sky130_ef_sc_hd__decap_12
XFILLER_67_39 VPWR VGND VPWR VGND sky130_ef_sc_hd__decap_12
XTAP_TAPCELL_ROW_70_726 VGND VPWR sky130_fd_sc_hd__tapvpwrvgnd_1
XFILLER_40_444 VGND VGND VPWR VPWR sky130_fd_sc_hd__decap_6
XFILLER_40_400 VGND VGND VPWR VPWR sky130_fd_sc_hd__decap_4
XFILLER_12_102 VPWR VGND VPWR VGND sky130_ef_sc_hd__decap_12
XFILLER_16_54 VPWR VGND VPWR VGND sky130_ef_sc_hd__decap_12
XFILLER_16_76 VGND VGND VPWR VPWR sky130_fd_sc_hd__decap_8
Xclkbuf_leaf_6_clock clknet_2_1__leaf_clock VGND VGND VPWR VPWR clknet_leaf_6_clock
+ sky130_fd_sc_hd__clkbuf_8
XFILLER_4_301 VGND VGND VPWR VPWR sky130_fd_sc_hd__decap_6
XFILLER_4_389 VPWR VGND VPWR VGND sky130_ef_sc_hd__decap_12
XFILLER_4_345 VPWR VGND VPWR VGND sky130_ef_sc_hd__decap_12
XFILLER_75_374 VPWR VGND VPWR VGND sky130_ef_sc_hd__decap_12
XFILLER_73_93 VPWR VGND VPWR VGND sky130_ef_sc_hd__decap_12
XFILLER_43_271 VGND VGND VPWR VPWR sky130_fd_sc_hd__decap_4
XTAP_TAPCELL_ROW_33_428 VGND VPWR sky130_fd_sc_hd__tapvpwrvgnd_1
X_1584_ scratch\[3\]\[17\] scratch\[2\]\[17\] VGND VGND VPWR VPWR _0517_ sky130_fd_sc_hd__or2_1
Xhold106 scratch\[2\]\[20\] VGND VGND VPWR VPWR net382 sky130_fd_sc_hd__dlygate4sd3_1
X_1722_ clknet_leaf_15_clock _0065_ VGND VGND VPWR VPWR scratch\[2\]\[21\] sky130_fd_sc_hd__dfxtp_1
XTAP_TAPCELL_ROW_41_494 VGND VPWR sky130_fd_sc_hd__tapvpwrvgnd_1
Xhold128 scratch\[3\]\[6\] VGND VGND VPWR VPWR net404 sky130_fd_sc_hd__dlygate4sd3_1
Xhold139 scratch\[3\]\[28\] VGND VGND VPWR VPWR net415 sky130_fd_sc_hd__dlygate4sd3_1
Xhold117 scratch\[3\]\[30\] VGND VGND VPWR VPWR net393 sky130_fd_sc_hd__dlygate4sd3_1
X_1653_ scratch\[3\]\[31\] scratch\[2\]\[31\] VGND VGND VPWR VPWR _0572_ sky130_fd_sc_hd__nand2_1
XFILLER_7_161 VGND VGND VPWR VPWR sky130_fd_sc_hd__decap_6
XPHY_EDGE_ROW_9_Right_9 VGND VGND VPWR VPWR sky130_fd_sc_hd__decap_3
XFILLER_66_396 VPWR VGND VPWR VGND sky130_ef_sc_hd__decap_12
XFILLER_26_249 VGND VGND VPWR VPWR sky130_fd_sc_hd__decap_3
X_1018_ scratch\[1\]\[29\] net217 _0750_ net258 net250 VGND VGND VPWR VPWR _0751_
+ sky130_fd_sc_hd__a221o_1
XFILLER_1_337 VPWR VGND VPWR VGND sky130_ef_sc_hd__decap_12
XFILLER_72_333 VPWR VGND VPWR VGND sky130_ef_sc_hd__decap_12
XTAP_TAPCELL_ROW_4_197 VGND VPWR sky130_fd_sc_hd__tapvpwrvgnd_1
XFILLER_17_216 VGND VGND VPWR VPWR sky130_fd_sc_hd__fill_1
XFILLER_72_377 VPWR VGND VPWR VGND sky130_ef_sc_hd__decap_12
XFILLER_13_411 VGND VGND VPWR VPWR sky130_fd_sc_hd__fill_1
XFILLER_4_153 VPWR VGND VPWR VGND sky130_ef_sc_hd__decap_12
XFILLER_67_149 VPWR VGND VPWR VGND sky130_ef_sc_hd__decap_12
XFILLER_67_105 VGND VGND VPWR VPWR sky130_fd_sc_hd__decap_6
XFILLER_48_352 VPWR VGND VPWR VGND sky130_ef_sc_hd__decap_12
XFILLER_4_197 VPWR VGND VPWR VGND sky130_ef_sc_hd__decap_12
XFILLER_63_322 VGND VGND VPWR VPWR sky130_fd_sc_hd__decap_8
XTAP_TAPCELL_ROW_46_531 VGND VPWR sky130_fd_sc_hd__tapvpwrvgnd_1
XFILLER_31_252 VGND VGND VPWR VPWR sky130_fd_sc_hd__decap_4
XFILLER_31_241 VGND VGND VPWR VPWR sky130_fd_sc_hd__decap_6
X_1705_ clknet_leaf_22_clock _0048_ VGND VGND VPWR VPWR scratch\[5\]\[15\] sky130_fd_sc_hd__dfxtp_1
X_1567_ net305 net107 _0503_ VGND VGND VPWR VPWR _0248_ sky130_fd_sc_hd__a21o_1
X_1636_ net41 _0558_ net140 VGND VGND VPWR VPWR _0559_ sky130_fd_sc_hd__mux2_1
XFILLER_64_29 VPWR VGND VPWR VGND sky130_ef_sc_hd__decap_12
XFILLER_39_363 VGND VGND VPWR VPWR sky130_fd_sc_hd__decap_3
X_1498_ scratch\[3\]\[0\] scratch\[2\]\[0\] VGND VGND VPWR VPWR _0448_ sky130_fd_sc_hd__nand2_1
XFILLER_54_388 VPWR VGND VPWR VGND sky130_ef_sc_hd__decap_12
XTAP_TAPCELL_ROW_52_578 VGND VPWR sky130_fd_sc_hd__tapvpwrvgnd_1
XTAP_TAPCELL_ROW_9_234 VGND VPWR sky130_fd_sc_hd__tapvpwrvgnd_1
XFILLER_38_63 VGND VGND VPWR VPWR sky130_fd_sc_hd__decap_6
XFILLER_1_167 VGND VGND VPWR VPWR sky130_fd_sc_hd__fill_1
XFILLER_72_141 VPWR VGND VPWR VGND sky130_ef_sc_hd__decap_12
XFILLER_60_314 VGND VGND VPWR VPWR sky130_fd_sc_hd__decap_3
XFILLER_45_366 VGND VGND VPWR VPWR sky130_fd_sc_hd__fill_2
XFILLER_45_322 VGND VGND VPWR VPWR sky130_fd_sc_hd__decap_4
XFILLER_38_74 VGND VGND VPWR VPWR sky130_fd_sc_hd__decap_3
Xclkbuf_leaf_24_clock clknet_2_0__leaf_clock VGND VGND VPWR VPWR clknet_leaf_24_clock
+ sky130_fd_sc_hd__clkbuf_8
XFILLER_70_83 VGND VGND VPWR VPWR sky130_fd_sc_hd__fill_1
Xclkload26 clknet_leaf_14_clock VGND VGND VPWR VPWR clkload26/Y sky130_fd_sc_hd__clkinvlp_4
Xclkload15 clknet_leaf_17_clock VGND VGND VPWR VPWR clkload15/Y sky130_fd_sc_hd__clkinvlp_4
XFILLER_9_201 VGND VGND VPWR VPWR sky130_fd_sc_hd__decap_8
XFILLER_9_223 VGND VGND VPWR VPWR sky130_fd_sc_hd__fill_1
XFILLER_9_289 VGND VGND VPWR VPWR sky130_fd_sc_hd__fill_1
XFILLER_13_285 VGND VGND VPWR VPWR sky130_fd_sc_hd__fill_1
XFILLER_62_7 VPWR VGND VPWR VGND sky130_ef_sc_hd__decap_12
XFILLER_55_6 VPWR VGND VPWR VGND sky130_ef_sc_hd__decap_12
X_1421_ _0411_ _0413_ VGND VGND VPWR VPWR _0414_ sky130_fd_sc_hd__nor2_1
X_1283_ net246 net167 scratch\[7\]\[19\] VGND VGND VPWR VPWR _0320_ sky130_fd_sc_hd__or3b_1
XFILLER_48_171 VGND VGND VPWR VPWR sky130_fd_sc_hd__fill_1
X_1352_ net147 _0360_ scratch\[0\]\[4\] VGND VGND VPWR VPWR _0362_ sky130_fd_sc_hd__a21oi_1
Xclkload9 clknet_leaf_2_clock VGND VGND VPWR VPWR clkload9/Y sky130_fd_sc_hd__inv_6
X_0998_ net259 _0733_ _0734_ VGND VGND VPWR VPWR _0735_ sky130_fd_sc_hd__a21o_1
XFILLER_59_425 VPWR VGND VPWR VGND sky130_ef_sc_hd__decap_12
Xfanout202 net203 VGND VGND VPWR VPWR net202 sky130_fd_sc_hd__buf_1
Xfanout246 net247 VGND VGND VPWR VPWR net246 sky130_fd_sc_hd__clkbuf_2
Xfanout224 net225 VGND VGND VPWR VPWR net224 sky130_fd_sc_hd__clkbuf_2
Xfanout213 net216 VGND VGND VPWR VPWR net213 sky130_fd_sc_hd__clkbuf_4
X_1619_ scratch\[3\]\[24\] scratch\[2\]\[24\] VGND VGND VPWR VPWR _0545_ sky130_fd_sc_hd__or2_1
XTAP_TAPCELL_ROW_6_215 VGND VPWR sky130_fd_sc_hd__tapvpwrvgnd_1
Xfanout268 net270 VGND VGND VPWR VPWR net268 sky130_fd_sc_hd__clkbuf_4
Xfanout257 net57 VGND VGND VPWR VPWR net257 sky130_fd_sc_hd__clkbuf_2
Xfanout235 _0581_ VGND VGND VPWR VPWR net235 sky130_fd_sc_hd__clkbuf_2
XTAP_TAPCELL_ROW_65_681 VGND VPWR sky130_fd_sc_hd__tapvpwrvgnd_1
XFILLER_54_141 VPWR VGND VPWR VGND sky130_ef_sc_hd__decap_12
XFILLER_27_300 VGND VGND VPWR VPWR sky130_fd_sc_hd__decap_8
XFILLER_50_391 VGND VGND VPWR VPWR sky130_fd_sc_hd__decap_3
XFILLER_24_21 VGND VGND VPWR VPWR sky130_fd_sc_hd__decap_6
XFILLER_2_421 VPWR VGND VPWR VGND sky130_ef_sc_hd__decap_12
XFILLER_65_417 VPWR VGND VPWR VGND sky130_ef_sc_hd__decap_12
XFILLER_49_51 VGND VGND VPWR VPWR sky130_fd_sc_hd__decap_4
XFILLER_1_69 VPWR VGND VPWR VGND sky130_ef_sc_hd__decap_12
XFILLER_60_188 VGND VGND VPWR VPWR sky130_fd_sc_hd__decap_8
XFILLER_60_166 VGND VGND VPWR VPWR sky130_fd_sc_hd__fill_1
XFILLER_60_133 VGND VGND VPWR VPWR sky130_fd_sc_hd__decap_6
XFILLER_45_130 VPWR VGND VPWR VGND sky130_ef_sc_hd__decap_12
X_0921_ scratch\[0\]\[13\] net224 _0669_ VGND VGND VPWR VPWR _0670_ sky130_fd_sc_hd__a21o_1
XPHY_EDGE_ROW_23_Left_99 VGND VGND VPWR VPWR sky130_fd_sc_hd__decap_3
XFILLER_41_391 VGND VGND VPWR VPWR sky130_fd_sc_hd__fill_1
XTAP_TAPCELL_ROW_11_250 VGND VPWR sky130_fd_sc_hd__tapvpwrvgnd_1
X_0852_ scratch\[4\]\[2\] scratch\[5\]\[2\] scratch\[6\]\[2\] scratch\[7\]\[2\] net264
+ net254 VGND VGND VPWR VPWR _0612_ sky130_fd_sc_hd__mux4_1
X_1404_ net204 _0395_ _0400_ VGND VGND VPWR VPWR _0401_ sky130_fd_sc_hd__and3_1
X_1335_ _0777_ _0345_ _0788_ VGND VGND VPWR VPWR _0349_ sky130_fd_sc_hd__a21o_1
XFILLER_5_281 VPWR VGND VPWR VGND sky130_ef_sc_hd__decap_12
XFILLER_68_288 VGND VGND VPWR VPWR sky130_fd_sc_hd__decap_4
X_1266_ net23 net162 _0311_ VGND VGND VPWR VPWR _0139_ sky130_fd_sc_hd__a21bo_1
X_1197_ net52 net171 _0276_ VGND VGND VPWR VPWR _0105_ sky130_fd_sc_hd__a21bo_1
XFILLER_56_417 VGND VGND VPWR VPWR sky130_fd_sc_hd__decap_3
Xinput2 host_input_addr[10] VGND VGND VPWR VPWR net2 sky130_fd_sc_hd__buf_1
XFILLER_51_111 VGND VGND VPWR VPWR sky130_fd_sc_hd__fill_1
XFILLER_36_152 VGND VGND VPWR VPWR sky130_fd_sc_hd__fill_1
XFILLER_36_141 VGND VGND VPWR VPWR sky130_fd_sc_hd__decap_3
XTAP_TAPCELL_ROW_62_662 VGND VPWR sky130_fd_sc_hd__tapvpwrvgnd_1
XFILLER_59_244 VGND VGND VPWR VPWR sky130_fd_sc_hd__decap_4
XFILLER_59_222 VGND VGND VPWR VPWR sky130_fd_sc_hd__fill_2
XFILLER_19_43 VPWR VGND VPWR VGND sky130_ef_sc_hd__decap_12
XFILLER_42_188 VGND VGND VPWR VPWR sky130_fd_sc_hd__decap_8
XFILLER_30_328 VGND VGND VPWR VPWR sky130_fd_sc_hd__fill_1
XFILLER_27_185 VPWR VGND VPWR VGND sky130_ef_sc_hd__decap_12
XFILLER_27_152 VPWR VGND VPWR VGND sky130_ef_sc_hd__decap_12
XTAP_TAPCELL_ROW_25_364 VGND VPWR sky130_fd_sc_hd__tapvpwrvgnd_1
XFILLER_2_251 VGND VGND VPWR VPWR sky130_fd_sc_hd__fill_1
XFILLER_38_417 VGND VGND VPWR VPWR sky130_fd_sc_hd__decap_3
X_1051_ net16 net15 _0774_ VGND VGND VPWR VPWR _0781_ sky130_fd_sc_hd__or3_1
XFILLER_33_111 VGND VGND VPWR VPWR sky130_fd_sc_hd__fill_1
XFILLER_18_141 VGND VGND VPWR VPWR sky130_fd_sc_hd__fill_1
X_1120_ net45 net184 net127 net354 VGND VGND VPWR VPWR _0063_ sky130_fd_sc_hd__a22o_1
X_0904_ net256 _0655_ VGND VGND VPWR VPWR _0656_ sky130_fd_sc_hd__and2_1
X_1884_ clknet_leaf_15_clock _0226_ VGND VGND VPWR VPWR scratch\[3\]\[23\] sky130_fd_sc_hd__dfxtp_1
XFILLER_33_166 VGND VGND VPWR VPWR sky130_fd_sc_hd__fill_2
X_0835_ scratch\[4\]\[0\] net222 _0596_ VGND VGND VPWR VPWR _0597_ sky130_fd_sc_hd__a21o_1
X_1318_ net72 net71 _0336_ VGND VGND VPWR VPWR _0339_ sky130_fd_sc_hd__and3_1
XFILLER_72_29 VPWR VGND VPWR VGND sky130_ef_sc_hd__decap_12
XFILLER_71_217 VGND VGND VPWR VPWR sky130_fd_sc_hd__decap_6
XTAP_TAPCELL_ROW_39_478 VGND VPWR sky130_fd_sc_hd__tapvpwrvgnd_1
XFILLER_24_177 VGND VGND VPWR VPWR sky130_fd_sc_hd__decap_8
X_1249_ net236 net159 scratch\[7\]\[2\] VGND VGND VPWR VPWR _0303_ sky130_fd_sc_hd__or3b_1
XFILLER_20_361 VGND VGND VPWR VPWR sky130_fd_sc_hd__decap_3
XFILLER_47_225 VGND VGND VPWR VPWR sky130_fd_sc_hd__decap_8
XFILLER_46_85 VGND VGND VPWR VPWR sky130_fd_sc_hd__fill_1
XFILLER_46_74 VGND VGND VPWR VPWR sky130_fd_sc_hd__decap_8
XFILLER_46_52 VGND VGND VPWR VPWR sky130_fd_sc_hd__decap_6
XTAP_TAPCELL_ROW_73_746 VGND VPWR sky130_fd_sc_hd__tapvpwrvgnd_1
XFILLER_15_133 VGND VGND VPWR VPWR sky130_fd_sc_hd__decap_8
XFILLER_7_57 VPWR VGND VPWR VGND sky130_ef_sc_hd__decap_12
XFILLER_11_361 VPWR VGND VPWR VGND sky130_ef_sc_hd__decap_12
XFILLER_16_3 VGND VGND VPWR VPWR sky130_fd_sc_hd__decap_3
XFILLER_53_239 VGND VGND VPWR VPWR sky130_fd_sc_hd__fill_1
X_1103_ net26 net185 net128 net328 VGND VGND VPWR VPWR _0046_ sky130_fd_sc_hd__a22o_1
XTAP_TAPCELL_ROW_36_448 VGND VPWR sky130_fd_sc_hd__tapvpwrvgnd_1
X_1034_ net253 _0763_ _0764_ VGND VGND VPWR VPWR _0765_ sky130_fd_sc_hd__a21o_1
X_1867_ clknet_leaf_0_clock _0209_ VGND VGND VPWR VPWR scratch\[3\]\[6\] sky130_fd_sc_hd__dfxtp_1
XFILLER_21_169 VGND VGND VPWR VPWR sky130_fd_sc_hd__decap_8
X_1798_ clknet_leaf_11_clock _0141_ VGND VGND VPWR VPWR scratch\[7\]\[12\] sky130_fd_sc_hd__dfxtp_1
X_0818_ net249 VGND VGND VPWR VPWR _0581_ sky130_fd_sc_hd__inv_2
Xinput60 host_output_addr[4] VGND VGND VPWR VPWR net60 sky130_fd_sc_hd__clkbuf_1
XPHY_EDGE_ROW_10_Left_86 VGND VGND VPWR VPWR sky130_fd_sc_hd__decap_3
XFILLER_69_361 VPWR VGND VPWR VGND sky130_ef_sc_hd__decap_12
XFILLER_29_225 VGND VGND VPWR VPWR sky130_fd_sc_hd__decap_8
XTAP_TAPCELL_ROW_70_727 VGND VPWR sky130_fd_sc_hd__tapvpwrvgnd_1
XFILLER_40_412 VGND VGND VPWR VPWR sky130_fd_sc_hd__decap_8
XFILLER_12_169 VGND VGND VPWR VPWR sky130_fd_sc_hd__fill_1
XFILLER_16_22 VGND VGND VPWR VPWR sky130_fd_sc_hd__decap_6
XFILLER_16_66 VGND VGND VPWR VPWR sky130_fd_sc_hd__fill_1
XFILLER_32_98 VGND VGND VPWR VPWR sky130_fd_sc_hd__decap_4
XFILLER_4_357 VGND VGND VPWR VPWR sky130_fd_sc_hd__decap_6
XFILLER_57_62 VGND VGND VPWR VPWR sky130_fd_sc_hd__fill_2
XFILLER_75_386 VGND VGND VPWR VPWR sky130_fd_sc_hd__decap_6
XFILLER_75_331 VGND VGND VPWR VPWR sky130_fd_sc_hd__decap_4
XFILLER_28_280 VPWR VGND VPWR VGND sky130_ef_sc_hd__decap_12
XTAP_TAPCELL_ROW_41_495 VGND VPWR sky130_fd_sc_hd__tapvpwrvgnd_1
XTAP_TAPCELL_ROW_33_429 VGND VPWR sky130_fd_sc_hd__tapvpwrvgnd_1
XFILLER_31_423 VGND VGND VPWR VPWR sky130_fd_sc_hd__fill_1
X_1721_ clknet_leaf_25_clock _0064_ VGND VGND VPWR VPWR scratch\[5\]\[31\] sky130_fd_sc_hd__dfxtp_1
Xhold129 scratch\[2\]\[14\] VGND VGND VPWR VPWR net405 sky130_fd_sc_hd__dlygate4sd3_1
Xhold118 scratch\[2\]\[9\] VGND VGND VPWR VPWR net394 sky130_fd_sc_hd__dlygate4sd3_1
X_1583_ scratch\[3\]\[17\] scratch\[2\]\[17\] VGND VGND VPWR VPWR _0516_ sky130_fd_sc_hd__nand2_1
Xhold107 scratch\[2\]\[4\] VGND VGND VPWR VPWR net383 sky130_fd_sc_hd__dlygate4sd3_1
X_1652_ net286 net108 _0571_ VGND VGND VPWR VPWR _0265_ sky130_fd_sc_hd__a21o_1
XFILLER_58_309 VGND VGND VPWR VPWR sky130_fd_sc_hd__decap_3
XFILLER_26_206 VGND VGND VPWR VPWR sky130_fd_sc_hd__decap_8
X_1017_ scratch\[2\]\[29\] scratch\[3\]\[29\] net268 VGND VGND VPWR VPWR _0750_ sky130_fd_sc_hd__mux2_1
X_1919_ clknet_leaf_20_clock _0261_ VGND VGND VPWR VPWR scratch\[1\]\[26\] sky130_fd_sc_hd__dfxtp_1
XFILLER_1_349 VPWR VGND VPWR VGND sky130_ef_sc_hd__decap_12
XFILLER_1_305 VPWR VGND VPWR VGND sky130_ef_sc_hd__decap_12
XFILLER_72_389 VPWR VGND VPWR VGND sky130_ef_sc_hd__decap_12
XFILLER_72_345 VPWR VGND VPWR VGND sky130_ef_sc_hd__decap_12
XFILLER_72_301 VGND VGND VPWR VPWR sky130_fd_sc_hd__decap_6
XFILLER_57_353 VGND VGND VPWR VPWR sky130_fd_sc_hd__fill_1
XFILLER_27_32 VGND VGND VPWR VPWR sky130_fd_sc_hd__fill_2
XTAP_TAPCELL_ROW_4_198 VGND VPWR sky130_fd_sc_hd__tapvpwrvgnd_1
XFILLER_40_253 VPWR VGND VPWR VGND sky130_ef_sc_hd__decap_12
XFILLER_9_405 VPWR VGND VPWR VGND sky130_ef_sc_hd__decap_12
XFILLER_9_449 VGND VGND VPWR VPWR sky130_fd_sc_hd__decap_4
XFILLER_4_165 VPWR VGND VPWR VGND sky130_ef_sc_hd__decap_12
XFILLER_4_121 VPWR VGND VPWR VGND sky130_ef_sc_hd__decap_12
XFILLER_75_150 VGND VGND VPWR VPWR sky130_fd_sc_hd__decap_8
XFILLER_68_83 VGND VGND VPWR VPWR sky130_fd_sc_hd__fill_1
XFILLER_0_393 VPWR VGND VPWR VGND sky130_ef_sc_hd__decap_12
XTAP_TAPCELL_ROW_46_532 VGND VPWR sky130_fd_sc_hd__tapvpwrvgnd_1
X_1704_ clknet_leaf_8_clock _0047_ VGND VGND VPWR VPWR scratch\[5\]\[14\] sky130_fd_sc_hd__dfxtp_1
X_1566_ net26 _0502_ net137 VGND VGND VPWR VPWR _0503_ sky130_fd_sc_hd__mux2_1
X_1497_ _0788_ net137 VGND VGND VPWR VPWR _0447_ sky130_fd_sc_hd__and2b_1
X_1635_ net199 _0556_ _0557_ VGND VGND VPWR VPWR _0558_ sky130_fd_sc_hd__and3_1
Xclkbuf_leaf_5_clock clknet_2_1__leaf_clock VGND VGND VPWR VPWR clknet_leaf_5_clock
+ sky130_fd_sc_hd__clkbuf_8
XTAP_TAPCELL_ROW_1_168 VGND VPWR sky130_fd_sc_hd__tapvpwrvgnd_1
XFILLER_14_209 VGND VGND VPWR VPWR sky130_fd_sc_hd__fill_2
XTAP_TAPCELL_ROW_52_579 VGND VPWR sky130_fd_sc_hd__tapvpwrvgnd_1
XFILLER_13_34 VGND VGND VPWR VPWR sky130_fd_sc_hd__fill_1
XFILLER_1_113 VPWR VGND VPWR VGND sky130_ef_sc_hd__decap_12
XFILLER_6_419 VGND VGND VPWR VPWR sky130_fd_sc_hd__fill_1
XTAP_TAPCELL_ROW_9_235 VGND VPWR sky130_fd_sc_hd__tapvpwrvgnd_1
XFILLER_64_109 VGND VGND VPWR VPWR sky130_fd_sc_hd__fill_2
XFILLER_49_139 VPWR VGND VPWR VGND sky130_ef_sc_hd__decap_12
XFILLER_72_197 VPWR VGND VPWR VGND sky130_ef_sc_hd__decap_12
XFILLER_72_153 VPWR VGND VPWR VGND sky130_ef_sc_hd__decap_12
XFILLER_54_96 VGND VGND VPWR VPWR sky130_fd_sc_hd__fill_1
XFILLER_54_74 VGND VGND VPWR VPWR sky130_fd_sc_hd__fill_1
XFILLER_54_41 VGND VGND VPWR VPWR sky130_fd_sc_hd__decap_8
Xclkload27 clknet_leaf_15_clock VGND VGND VPWR VPWR clkload27/X sky130_fd_sc_hd__clkbuf_8
Xclkload16 clknet_leaf_18_clock VGND VGND VPWR VPWR clkload16/Y sky130_fd_sc_hd__clkinv_2
XFILLER_9_257 VGND VGND VPWR VPWR sky130_fd_sc_hd__decap_3
X_1420_ net150 _0401_ _0412_ VGND VGND VPWR VPWR _0413_ sky130_fd_sc_hd__and3_1
X_1351_ net47 net155 net117 _0361_ VGND VGND VPWR VPWR _0174_ sky130_fd_sc_hd__a22o_1
XFILLER_5_441 VGND VGND VPWR VPWR sky130_fd_sc_hd__decap_6
XFILLER_63_120 VGND VGND VPWR VPWR sky130_fd_sc_hd__fill_1
X_1282_ net31 net164 _0319_ VGND VGND VPWR VPWR _0147_ sky130_fd_sc_hd__a21bo_1
XFILLER_63_186 VGND VGND VPWR VPWR sky130_fd_sc_hd__decap_8
XFILLER_51_337 VGND VGND VPWR VPWR sky130_fd_sc_hd__decap_6
XFILLER_36_389 VGND VGND VPWR VPWR sky130_fd_sc_hd__decap_4
X_1618_ scratch\[3\]\[24\] scratch\[2\]\[24\] VGND VGND VPWR VPWR _0544_ sky130_fd_sc_hd__nand2_1
X_0997_ scratch\[4\]\[25\] net227 net218 scratch\[5\]\[25\] net234 VGND VGND VPWR
+ VPWR _0734_ sky130_fd_sc_hd__a221o_1
XFILLER_75_29 VPWR VGND VPWR VGND sky130_ef_sc_hd__decap_12
XFILLER_59_437 VGND VGND VPWR VPWR sky130_fd_sc_hd__decap_8
XTAP_TAPCELL_ROW_57_616 VGND VPWR sky130_fd_sc_hd__tapvpwrvgnd_1
X_1549_ scratch\[3\]\[10\] scratch\[2\]\[10\] VGND VGND VPWR VPWR _0489_ sky130_fd_sc_hd__or2_1
Xfanout214 net216 VGND VGND VPWR VPWR net214 sky130_fd_sc_hd__buf_2
Xfanout225 _0587_ VGND VGND VPWR VPWR net225 sky130_fd_sc_hd__clkbuf_2
Xfanout203 _0000_ VGND VGND VPWR VPWR net203 sky130_fd_sc_hd__clkbuf_2
Xfanout236 net239 VGND VGND VPWR VPWR net236 sky130_fd_sc_hd__clkbuf_2
Xfanout247 net66 VGND VGND VPWR VPWR net247 sky130_fd_sc_hd__buf_2
Xfanout258 net259 VGND VGND VPWR VPWR net258 sky130_fd_sc_hd__buf_2
Xfanout269 net270 VGND VGND VPWR VPWR net269 sky130_fd_sc_hd__clkbuf_4
XTAP_TAPCELL_ROW_65_682 VGND VPWR sky130_fd_sc_hd__tapvpwrvgnd_1
XFILLER_54_197 VGND VGND VPWR VPWR sky130_fd_sc_hd__decap_6
XFILLER_54_153 VPWR VGND VPWR VGND sky130_ef_sc_hd__decap_12
XFILLER_2_433 VPWR VGND VPWR VGND sky130_ef_sc_hd__decap_12
XFILLER_65_429 VPWR VGND VPWR VGND sky130_ef_sc_hd__decap_12
XFILLER_65_51 VGND VGND VPWR VPWR sky130_fd_sc_hd__decap_4
XFILLER_45_142 VPWR VGND VPWR VGND sky130_ef_sc_hd__decap_12
XFILLER_1_15 VPWR VGND VPWR VGND sky130_ef_sc_hd__decap_12
XFILLER_45_164 VGND VGND VPWR VPWR sky130_fd_sc_hd__decap_4
X_0920_ scratch\[1\]\[13\] net215 _0668_ net256 net248 VGND VGND VPWR VPWR _0669_
+ sky130_fd_sc_hd__a221o_1
XFILLER_33_337 VGND VGND VPWR VPWR sky130_fd_sc_hd__decap_8
XTAP_TAPCELL_ROW_28_384 VGND VPWR sky130_fd_sc_hd__tapvpwrvgnd_1
X_0851_ net254 _0609_ _0610_ VGND VGND VPWR VPWR _0611_ sky130_fd_sc_hd__a21o_1
XTAP_TAPCELL_ROW_11_251 VGND VPWR sky130_fd_sc_hd__tapvpwrvgnd_1
X_1265_ net240 net162 scratch\[7\]\[10\] VGND VGND VPWR VPWR _0311_ sky130_fd_sc_hd__or3b_1
X_1403_ scratch\[0\]\[16\] scratch\[0\]\[17\] VGND VGND VPWR VPWR _0400_ sky130_fd_sc_hd__and2_1
X_1334_ _0777_ _0345_ _0788_ VGND VGND VPWR VPWR _0348_ sky130_fd_sc_hd__a21oi_4
XFILLER_5_293 VPWR VGND VPWR VGND sky130_ef_sc_hd__decap_12
XPHY_EDGE_ROW_18_Right_18 VGND VGND VPWR VPWR sky130_fd_sc_hd__decap_3
Xinput3 host_input_addr[11] VGND VGND VPWR VPWR net3 sky130_fd_sc_hd__buf_1
X_1196_ net241 net171 scratch\[6\]\[8\] VGND VGND VPWR VPWR _0276_ sky130_fd_sc_hd__or3b_1
XFILLER_36_197 VGND VGND VPWR VPWR sky130_fd_sc_hd__decap_8
XFILLER_36_175 VGND VGND VPWR VPWR sky130_fd_sc_hd__fill_1
XPHY_EDGE_ROW_27_Right_27 VGND VGND VPWR VPWR sky130_fd_sc_hd__decap_3
XFILLER_24_337 VGND VGND VPWR VPWR sky130_fd_sc_hd__fill_1
XTAP_TAPCELL_ROW_62_663 VGND VPWR sky130_fd_sc_hd__tapvpwrvgnd_1
XFILLER_51_167 VGND VGND VPWR VPWR sky130_fd_sc_hd__fill_1
XPHY_EDGE_ROW_36_Right_36 VGND VGND VPWR VPWR sky130_fd_sc_hd__decap_3
Xclkbuf_leaf_23_clock clknet_2_2__leaf_clock VGND VGND VPWR VPWR clknet_leaf_23_clock
+ sky130_fd_sc_hd__clkbuf_8
XFILLER_27_120 VGND VGND VPWR VPWR sky130_fd_sc_hd__decap_6
XFILLER_19_55 VGND VGND VPWR VPWR sky130_fd_sc_hd__fill_1
XFILLER_70_421 VPWR VGND VPWR VGND sky130_ef_sc_hd__decap_12
XPHY_EDGE_ROW_45_Right_45 VGND VGND VPWR VPWR sky130_fd_sc_hd__decap_3
XFILLER_35_54 VGND VGND VPWR VPWR sky130_fd_sc_hd__fill_2
XFILLER_27_197 VPWR VGND VPWR VGND sky130_ef_sc_hd__decap_12
XFILLER_27_164 VGND VGND VPWR VPWR sky130_fd_sc_hd__fill_1
XTAP_TAPCELL_ROW_25_365 VGND VPWR sky130_fd_sc_hd__tapvpwrvgnd_1
XFILLER_15_337 VPWR VGND VPWR VGND sky130_ef_sc_hd__decap_12
XPHY_EDGE_ROW_54_Right_54 VGND VGND VPWR VPWR sky130_fd_sc_hd__decap_3
XPHY_EDGE_ROW_29_Left_105 VGND VGND VPWR VPWR sky130_fd_sc_hd__decap_3
XFILLER_73_281 VPWR VGND VPWR VGND sky130_ef_sc_hd__decap_12
XPHY_EDGE_ROW_63_Right_63 VGND VGND VPWR VPWR sky130_fd_sc_hd__decap_3
X_1050_ _0770_ _0773_ _0775_ _0779_ VGND VGND VPWR VPWR _0780_ sky130_fd_sc_hd__or4_1
XPHY_EDGE_ROW_38_Left_114 VGND VGND VPWR VPWR sky130_fd_sc_hd__decap_3
XFILLER_33_134 VGND VGND VPWR VPWR sky130_fd_sc_hd__decap_3
XFILLER_18_197 VGND VGND VPWR VPWR sky130_fd_sc_hd__decap_4
X_0903_ scratch\[6\]\[10\] scratch\[7\]\[10\] net266 VGND VGND VPWR VPWR _0655_ sky130_fd_sc_hd__mux2_1
X_1883_ clknet_leaf_16_clock _0225_ VGND VGND VPWR VPWR scratch\[3\]\[22\] sky130_fd_sc_hd__dfxtp_1
X_0834_ scratch\[5\]\[0\] net216 _0595_ net253 net231 VGND VGND VPWR VPWR _0596_ sky130_fd_sc_hd__a221o_1
XPHY_EDGE_ROW_72_Right_72 VGND VGND VPWR VPWR sky130_fd_sc_hd__decap_3
XPHY_EDGE_ROW_47_Left_123 VGND VGND VPWR VPWR sky130_fd_sc_hd__decap_3
XTAP_TAPCELL_ROW_67_700 VGND VPWR sky130_fd_sc_hd__tapvpwrvgnd_1
X_1317_ net71 _0336_ net72 VGND VGND VPWR VPWR _0338_ sky130_fd_sc_hd__a21o_1
X_1248_ net33 net159 _0302_ VGND VGND VPWR VPWR _0130_ sky130_fd_sc_hd__a21bo_1
XPHY_EDGE_ROW_56_Left_132 VGND VGND VPWR VPWR sky130_fd_sc_hd__decap_3
XTAP_TAPCELL_ROW_39_479 VGND VPWR sky130_fd_sc_hd__tapvpwrvgnd_1
X_1179_ net12 net274 _0578_ _0782_ VGND VGND VPWR VPWR _0267_ sky130_fd_sc_hd__and4_2
XPHY_EDGE_ROW_65_Left_141 VGND VGND VPWR VPWR sky130_fd_sc_hd__decap_3
XPHY_EDGE_ROW_74_Left_150 VGND VGND VPWR VPWR sky130_fd_sc_hd__decap_3
XTAP_TAPCELL_ROW_73_747 VGND VPWR sky130_fd_sc_hd__tapvpwrvgnd_1
XFILLER_62_229 VGND VGND VPWR VPWR sky130_fd_sc_hd__fill_1
XFILLER_70_251 VGND VGND VPWR VPWR sky130_fd_sc_hd__fill_1
XFILLER_62_41 VGND VGND VPWR VPWR sky130_fd_sc_hd__fill_1
XFILLER_11_373 VPWR VGND VPWR VGND sky130_ef_sc_hd__decap_12
XFILLER_15_167 VGND VGND VPWR VPWR sky130_fd_sc_hd__fill_1
XFILLER_7_69 VPWR VGND VPWR VGND sky130_ef_sc_hd__decap_12
X_1102_ net25 net186 net129 net311 VGND VGND VPWR VPWR _0045_ sky130_fd_sc_hd__a22o_1
XFILLER_46_292 VGND VGND VPWR VPWR sky130_fd_sc_hd__decap_4
XTAP_TAPCELL_ROW_36_449 VGND VPWR sky130_fd_sc_hd__tapvpwrvgnd_1
X_1033_ scratch\[4\]\[31\] net225 net213 scratch\[5\]\[31\] net231 VGND VGND VPWR
+ VPWR _0764_ sky130_fd_sc_hd__a221o_1
X_1797_ clknet_leaf_11_clock _0140_ VGND VGND VPWR VPWR scratch\[7\]\[11\] sky130_fd_sc_hd__dfxtp_1
X_1866_ clknet_leaf_5_clock _0208_ VGND VGND VPWR VPWR scratch\[3\]\[5\] sky130_fd_sc_hd__dfxtp_1
Xinput50 host_input_data[6] VGND VGND VPWR VPWR net50 sky130_fd_sc_hd__clkbuf_2
X_0817_ net439 VGND VGND VPWR VPWR _0580_ sky130_fd_sc_hd__inv_2
Xinput61 host_output_addr[5] VGND VGND VPWR VPWR net61 sky130_fd_sc_hd__clkbuf_1
XFILLER_69_373 VPWR VGND VPWR VGND sky130_ef_sc_hd__decap_12
XFILLER_37_270 VGND VGND VPWR VPWR sky130_fd_sc_hd__fill_2
XFILLER_52_251 VGND VGND VPWR VPWR sky130_fd_sc_hd__fill_1
XFILLER_32_33 VGND VGND VPWR VPWR sky130_fd_sc_hd__fill_1
XPHY_EDGE_ROW_0_Right_0 VGND VGND VPWR VPWR sky130_fd_sc_hd__decap_3
XFILLER_75_365 VGND VGND VPWR VPWR sky130_fd_sc_hd__decap_4
XFILLER_73_51 VGND VGND VPWR VPWR sky130_fd_sc_hd__decap_4
XFILLER_35_229 VGND VGND VPWR VPWR sky130_fd_sc_hd__decap_6
XFILLER_28_292 VPWR VGND VPWR VGND sky130_ef_sc_hd__decap_12
Xhold108 scratch\[2\]\[8\] VGND VGND VPWR VPWR net384 sky130_fd_sc_hd__dlygate4sd3_1
X_1651_ net45 _0570_ net137 VGND VGND VPWR VPWR _0571_ sky130_fd_sc_hd__mux2_1
XFILLER_11_192 VPWR VGND VPWR VGND sky130_ef_sc_hd__decap_12
X_1720_ clknet_leaf_25_clock _0063_ VGND VGND VPWR VPWR scratch\[5\]\[30\] sky130_fd_sc_hd__dfxtp_1
X_1582_ net288 net110 _0515_ VGND VGND VPWR VPWR _0251_ sky130_fd_sc_hd__a21o_1
Xhold119 scratch\[3\]\[1\] VGND VGND VPWR VPWR net395 sky130_fd_sc_hd__dlygate4sd3_1
XFILLER_3_391 VGND VGND VPWR VPWR sky130_fd_sc_hd__fill_1
XTAP_TAPCELL_ROW_49_552 VGND VPWR sky130_fd_sc_hd__tapvpwrvgnd_1
XFILLER_19_281 VGND VGND VPWR VPWR sky130_fd_sc_hd__fill_1
XFILLER_34_262 VGND VGND VPWR VPWR sky130_fd_sc_hd__fill_1
XFILLER_34_251 VGND VGND VPWR VPWR sky130_fd_sc_hd__fill_1
X_1016_ net208 _0746_ _0749_ VGND VGND VPWR VPWR net95 sky130_fd_sc_hd__and3_1
X_1849_ clknet_leaf_15_clock _0191_ VGND VGND VPWR VPWR scratch\[0\]\[20\] sky130_fd_sc_hd__dfxtp_1
X_1918_ clknet_leaf_21_clock _0260_ VGND VGND VPWR VPWR scratch\[1\]\[25\] sky130_fd_sc_hd__dfxtp_1
XFILLER_1_317 VPWR VGND VPWR VGND sky130_ef_sc_hd__decap_12
XFILLER_72_357 VGND VGND VPWR VPWR sky130_fd_sc_hd__decap_6
XTAP_TAPCELL_ROW_4_199 VGND VPWR sky130_fd_sc_hd__tapvpwrvgnd_1
XFILLER_43_54 VGND VGND VPWR VPWR sky130_fd_sc_hd__fill_2
XFILLER_9_417 VPWR VGND VPWR VGND sky130_ef_sc_hd__decap_12
XFILLER_4_177 VPWR VGND VPWR VGND sky130_ef_sc_hd__decap_12
XFILLER_4_133 VGND VGND VPWR VPWR sky130_fd_sc_hd__decap_6
XFILLER_4_15 VPWR VGND VPWR VGND sky130_ef_sc_hd__decap_12
XFILLER_75_195 VGND VGND VPWR VPWR sky130_fd_sc_hd__fill_1
XFILLER_75_173 VGND VGND VPWR VPWR sky130_fd_sc_hd__fill_1
XFILLER_48_365 VGND VGND VPWR VPWR sky130_fd_sc_hd__decap_8
XTAP_TAPCELL_ROW_46_533 VGND VPWR sky130_fd_sc_hd__tapvpwrvgnd_1
XFILLER_0_361 VGND VGND VPWR VPWR sky130_fd_sc_hd__decap_3
XFILLER_16_251 VGND VGND VPWR VPWR sky130_fd_sc_hd__fill_1
X_1703_ clknet_leaf_2_clock _0046_ VGND VGND VPWR VPWR scratch\[5\]\[13\] sky130_fd_sc_hd__dfxtp_1
X_1634_ scratch\[3\]\[27\] scratch\[2\]\[27\] VGND VGND VPWR VPWR _0557_ sky130_fd_sc_hd__or2_1
X_1565_ net198 _0500_ _0501_ VGND VGND VPWR VPWR _0502_ sky130_fd_sc_hd__and3_1
X_1496_ _0768_ _0786_ VGND VGND VPWR VPWR _0446_ sky130_fd_sc_hd__or2_1
XTAP_TAPCELL_ROW_1_169 VGND VPWR sky130_fd_sc_hd__tapvpwrvgnd_1
XFILLER_10_449 VGND VGND VPWR VPWR sky130_fd_sc_hd__fill_1
XFILLER_13_57 VPWR VGND VPWR VGND sky130_ef_sc_hd__decap_12
XFILLER_1_125 VPWR VGND VPWR VGND sky130_ef_sc_hd__decap_12
XFILLER_8_6 VPWR VGND VPWR VGND sky130_ef_sc_hd__decap_12
XTAP_TAPCELL_ROW_9_236 VGND VPWR sky130_fd_sc_hd__tapvpwrvgnd_1
XFILLER_72_121 VPWR VGND VPWR VGND sky130_ef_sc_hd__decap_12
XFILLER_49_107 VGND VGND VPWR VPWR sky130_fd_sc_hd__decap_4
XFILLER_1_169 VPWR VGND VPWR VGND sky130_ef_sc_hd__decap_12
XFILLER_72_165 VPWR VGND VPWR VGND sky130_ef_sc_hd__decap_12
XFILLER_45_346 VGND VGND VPWR VPWR sky130_fd_sc_hd__fill_1
XFILLER_9_225 VGND VGND VPWR VPWR sky130_fd_sc_hd__decap_8
XFILLER_13_276 VGND VGND VPWR VPWR sky130_fd_sc_hd__decap_4
XFILLER_70_85 VPWR VGND VPWR VGND sky130_ef_sc_hd__decap_12
XFILLER_70_41 VPWR VGND VPWR VGND sky130_ef_sc_hd__decap_12
Xclkload17 clknet_leaf_20_clock VGND VGND VPWR VPWR clkload17/Y sky130_fd_sc_hd__inv_8
XFILLER_48_7 VGND VGND VPWR VPWR sky130_fd_sc_hd__decap_6
X_1281_ net243 net164 scratch\[7\]\[18\] VGND VGND VPWR VPWR _0319_ sky130_fd_sc_hd__or3b_1
X_1350_ net149 _0360_ _0357_ VGND VGND VPWR VPWR _0361_ sky130_fd_sc_hd__a21boi_1
XFILLER_48_195 VGND VGND VPWR VPWR sky130_fd_sc_hd__fill_1
XFILLER_36_379 VGND VGND VPWR VPWR sky130_fd_sc_hd__fill_1
XFILLER_36_313 VPWR VGND VPWR VGND sky130_ef_sc_hd__decap_12
X_0996_ scratch\[6\]\[25\] scratch\[7\]\[25\] net269 VGND VGND VPWR VPWR _0733_ sky130_fd_sc_hd__mux2_1
Xfanout204 _0371_ VGND VGND VPWR VPWR net204 sky130_fd_sc_hd__clkbuf_2
X_1617_ net283 net110 _0543_ VGND VGND VPWR VPWR _0258_ sky130_fd_sc_hd__a21o_1
XFILLER_74_419 VGND VGND VPWR VPWR sky130_fd_sc_hd__fill_1
XFILLER_59_449 VGND VGND VPWR VPWR sky130_fd_sc_hd__decap_4
XTAP_TAPCELL_ROW_57_617 VGND VPWR sky130_fd_sc_hd__tapvpwrvgnd_1
X_1548_ scratch\[3\]\[10\] scratch\[2\]\[10\] VGND VGND VPWR VPWR _0488_ sky130_fd_sc_hd__nand2_1
Xfanout215 net216 VGND VGND VPWR VPWR net215 sky130_fd_sc_hd__clkbuf_2
Xfanout248 net252 VGND VGND VPWR VPWR net248 sky130_fd_sc_hd__clkbuf_4
XFILLER_39_195 VGND VGND VPWR VPWR sky130_fd_sc_hd__decap_6
Xfanout226 net230 VGND VGND VPWR VPWR net226 sky130_fd_sc_hd__clkbuf_4
X_1479_ net28 net144 net114 net410 VGND VGND VPWR VPWR _0218_ sky130_fd_sc_hd__a22o_1
Xfanout237 net239 VGND VGND VPWR VPWR net237 sky130_fd_sc_hd__clkbuf_2
Xfanout259 net262 VGND VGND VPWR VPWR net259 sky130_fd_sc_hd__clkbuf_4
XTAP_TAPCELL_ROW_65_683 VGND VPWR sky130_fd_sc_hd__tapvpwrvgnd_1
XFILLER_54_165 VGND VGND VPWR VPWR sky130_fd_sc_hd__decap_8
XFILLER_10_246 VGND VGND VPWR VPWR sky130_fd_sc_hd__fill_1
XFILLER_2_445 VGND VGND VPWR VPWR sky130_fd_sc_hd__decap_8
XFILLER_2_401 VPWR VGND VPWR VGND sky130_ef_sc_hd__decap_12
XFILLER_73_441 VGND VGND VPWR VPWR sky130_fd_sc_hd__decap_6
XFILLER_45_154 VGND VGND VPWR VPWR sky130_fd_sc_hd__decap_6
XFILLER_1_27 VPWR VGND VPWR VGND sky130_ef_sc_hd__decap_12
XFILLER_41_393 VGND VGND VPWR VPWR sky130_fd_sc_hd__decap_6
XTAP_TAPCELL_ROW_28_385 VGND VPWR sky130_fd_sc_hd__tapvpwrvgnd_1
X_0850_ scratch\[0\]\[2\] net222 net213 scratch\[1\]\[2\] net249 VGND VGND VPWR VPWR
+ _0610_ sky130_fd_sc_hd__a221o_1
Xclkbuf_leaf_4_clock clknet_2_1__leaf_clock VGND VGND VPWR VPWR clknet_leaf_4_clock
+ sky130_fd_sc_hd__clkbuf_8
X_1402_ net29 net156 _0399_ VGND VGND VPWR VPWR _0187_ sky130_fd_sc_hd__a21bo_1
XFILLER_5_261 VPWR VGND VPWR VGND sky130_ef_sc_hd__decap_12
XTAP_TAPCELL_ROW_11_252 VGND VPWR sky130_fd_sc_hd__tapvpwrvgnd_1
Xinput4 host_input_addr[12] VGND VGND VPWR VPWR net4 sky130_fd_sc_hd__buf_1
XFILLER_68_224 VPWR VGND VPWR VGND sky130_ef_sc_hd__decap_12
X_1264_ net53 net162 _0310_ VGND VGND VPWR VPWR _0138_ sky130_fd_sc_hd__a21bo_1
XFILLER_39_3 VPWR VGND VPWR VGND sky130_ef_sc_hd__decap_12
X_1333_ net276 net274 _0578_ _0782_ VGND VGND VPWR VPWR _0347_ sky130_fd_sc_hd__and4bb_1
X_1195_ net51 net171 _0275_ VGND VGND VPWR VPWR _0104_ sky130_fd_sc_hd__a21bo_1
XFILLER_51_113 VPWR VGND VPWR VGND sky130_ef_sc_hd__decap_12
XFILLER_17_390 VGND VGND VPWR VPWR sky130_fd_sc_hd__fill_2
X_0979_ scratch\[6\]\[22\] scratch\[7\]\[22\] net269 VGND VGND VPWR VPWR _0719_ sky130_fd_sc_hd__mux2_1
XFILLER_59_257 VGND VGND VPWR VPWR sky130_fd_sc_hd__fill_1
XFILLER_70_433 VPWR VGND VPWR VGND sky130_ef_sc_hd__decap_12
XFILLER_50_190 VGND VGND VPWR VPWR sky130_fd_sc_hd__decap_6
XTAP_TAPCELL_ROW_25_366 VGND VPWR sky130_fd_sc_hd__tapvpwrvgnd_1
XFILLER_15_349 VPWR VGND VPWR VGND sky130_ef_sc_hd__decap_12
XFILLER_38_408 VGND VGND VPWR VPWR sky130_fd_sc_hd__fill_1
XFILLER_2_253 VPWR VGND VPWR VGND sky130_ef_sc_hd__decap_12
XFILLER_73_293 VPWR VGND VPWR VGND sky130_ef_sc_hd__decap_12
XFILLER_18_121 VPWR VGND VPWR VGND sky130_ef_sc_hd__decap_12
XFILLER_21_319 VPWR VGND VPWR VGND sky130_ef_sc_hd__decap_12
X_0902_ scratch\[0\]\[10\] scratch\[2\]\[10\] scratch\[1\]\[10\] scratch\[3\]\[10\]
+ net256 net266 VGND VGND VPWR VPWR _0654_ sky130_fd_sc_hd__mux4_1
X_1882_ clknet_leaf_15_clock _0224_ VGND VGND VPWR VPWR scratch\[3\]\[21\] sky130_fd_sc_hd__dfxtp_1
X_0833_ scratch\[6\]\[0\] scratch\[7\]\[0\] net263 VGND VGND VPWR VPWR _0595_ sky130_fd_sc_hd__mux2_1
XFILLER_14_360 VGND VGND VPWR VPWR sky130_fd_sc_hd__decap_4
XTAP_TAPCELL_ROW_67_701 VGND VPWR sky130_fd_sc_hd__tapvpwrvgnd_1
X_1178_ net12 net275 VGND VGND VPWR VPWR _0812_ sky130_fd_sc_hd__nand2_1
X_1247_ net236 net159 scratch\[7\]\[1\] VGND VGND VPWR VPWR _0302_ sky130_fd_sc_hd__or3b_1
X_1316_ net71 _0336_ _0337_ VGND VGND VPWR VPWR _0163_ sky130_fd_sc_hd__o21a_1
XTAP_TAPCELL_ROW_22_336 VGND VPWR sky130_fd_sc_hd__tapvpwrvgnd_1
XFILLER_47_216 VGND VGND VPWR VPWR sky130_fd_sc_hd__decap_8
XTAP_TAPCELL_ROW_73_748 VGND VPWR sky130_fd_sc_hd__tapvpwrvgnd_1
XFILLER_55_293 VGND VGND VPWR VPWR sky130_fd_sc_hd__fill_1
XFILLER_55_260 VPWR VGND VPWR VGND sky130_ef_sc_hd__decap_12
XFILLER_47_238 VPWR VGND VPWR VGND sky130_ef_sc_hd__decap_12
XFILLER_28_452 VGND VGND VPWR VPWR sky130_fd_sc_hd__fill_1
XFILLER_11_385 VGND VGND VPWR VPWR sky130_fd_sc_hd__decap_6
X_1101_ net24 net186 net129 net352 VGND VGND VPWR VPWR _0044_ sky130_fd_sc_hd__a22o_1
X_1032_ scratch\[6\]\[31\] scratch\[7\]\[31\] net263 VGND VGND VPWR VPWR _0763_ sky130_fd_sc_hd__mux2_1
XFILLER_46_282 VGND VGND VPWR VPWR sky130_fd_sc_hd__fill_1
Xclkbuf_leaf_22_clock clknet_2_2__leaf_clock VGND VGND VPWR VPWR clknet_leaf_22_clock
+ sky130_fd_sc_hd__clkbuf_8
X_1796_ clknet_leaf_6_clock _0139_ VGND VGND VPWR VPWR scratch\[7\]\[10\] sky130_fd_sc_hd__dfxtp_1
Xinput51 host_input_data[7] VGND VGND VPWR VPWR net51 sky130_fd_sc_hd__buf_2
X_1865_ clknet_leaf_2_clock _0207_ VGND VGND VPWR VPWR scratch\[3\]\[4\] sky130_fd_sc_hd__dfxtp_1
X_0816_ scratch\[0\]\[24\] VGND VGND VPWR VPWR _0579_ sky130_fd_sc_hd__inv_2
Xinput62 host_output_addr[6] VGND VGND VPWR VPWR net62 sky130_fd_sc_hd__clkbuf_1
Xinput40 host_input_data[26] VGND VGND VPWR VPWR net40 sky130_fd_sc_hd__clkbuf_2
XFILLER_69_385 VGND VGND VPWR VPWR sky130_fd_sc_hd__decap_6
XFILLER_29_205 VGND VGND VPWR VPWR sky130_fd_sc_hd__decap_3
XFILLER_75_355 VGND VGND VPWR VPWR sky130_fd_sc_hd__fill_1
XFILLER_16_400 VGND VGND VPWR VPWR sky130_fd_sc_hd__decap_8
XFILLER_16_444 VGND VGND VPWR VPWR sky130_fd_sc_hd__decap_6
Xhold109 scratch\[2\]\[17\] VGND VGND VPWR VPWR net385 sky130_fd_sc_hd__dlygate4sd3_1
X_1581_ net29 _0514_ net140 VGND VGND VPWR VPWR _0515_ sky130_fd_sc_hd__mux2_1
X_1650_ net198 _0568_ _0569_ VGND VGND VPWR VPWR _0570_ sky130_fd_sc_hd__and3_1
XTAP_TAPCELL_ROW_49_553 VGND VPWR sky130_fd_sc_hd__tapvpwrvgnd_1
X_1015_ net258 _0747_ _0748_ VGND VGND VPWR VPWR _0749_ sky130_fd_sc_hd__a21o_1
XFILLER_19_260 VGND VGND VPWR VPWR sky130_fd_sc_hd__decap_3
XTAP_TAPCELL_ROW_32_420 VGND VPWR sky130_fd_sc_hd__tapvpwrvgnd_1
X_1917_ clknet_leaf_23_clock _0259_ VGND VGND VPWR VPWR scratch\[1\]\[24\] sky130_fd_sc_hd__dfxtp_1
X_1848_ clknet_leaf_10_clock _0190_ VGND VGND VPWR VPWR scratch\[0\]\[19\] sky130_fd_sc_hd__dfxtp_1
XFILLER_1_329 VGND VGND VPWR VPWR sky130_fd_sc_hd__decap_6
XFILLER_8_91 VGND VGND VPWR VPWR sky130_fd_sc_hd__fill_1
X_1779_ clknet_leaf_20_clock _0122_ VGND VGND VPWR VPWR scratch\[6\]\[25\] sky130_fd_sc_hd__dfxtp_1
XFILLER_13_447 VGND VGND VPWR VPWR sky130_fd_sc_hd__fill_1
XFILLER_40_299 VGND VGND VPWR VPWR sky130_fd_sc_hd__decap_8
XFILLER_9_429 VPWR VGND VPWR VGND sky130_ef_sc_hd__decap_12
XFILLER_68_85 VPWR VGND VPWR VGND sky130_ef_sc_hd__decap_12
XFILLER_68_41 VPWR VGND VPWR VGND sky130_ef_sc_hd__decap_12
XFILLER_4_189 VGND VGND VPWR VPWR sky130_fd_sc_hd__decap_6
XFILLER_4_27 VGND VGND VPWR VPWR sky130_fd_sc_hd__fill_1
XFILLER_75_185 VGND VGND VPWR VPWR sky130_fd_sc_hd__decap_3
XFILLER_75_141 VGND VGND VPWR VPWR sky130_fd_sc_hd__decap_4
XTAP_TAPCELL_ROW_46_534 VGND VPWR sky130_fd_sc_hd__tapvpwrvgnd_1
XFILLER_71_391 VGND VGND VPWR VPWR sky130_fd_sc_hd__fill_1
XFILLER_31_222 VGND VGND VPWR VPWR sky130_fd_sc_hd__fill_2
XFILLER_69_3 VPWR VGND VPWR VGND sky130_ef_sc_hd__decap_12
X_1702_ clknet_leaf_9_clock _0045_ VGND VGND VPWR VPWR scratch\[5\]\[12\] sky130_fd_sc_hd__dfxtp_1
X_1564_ scratch\[3\]\[13\] scratch\[2\]\[13\] VGND VGND VPWR VPWR _0501_ sky130_fd_sc_hd__or2_1
X_1633_ scratch\[3\]\[27\] scratch\[2\]\[27\] VGND VGND VPWR VPWR _0556_ sky130_fd_sc_hd__nand2_1
XFILLER_39_355 VGND VGND VPWR VPWR sky130_fd_sc_hd__decap_8
XFILLER_39_311 VGND VGND VPWR VPWR sky130_fd_sc_hd__fill_1
X_1495_ net46 net142 net112 net423 VGND VGND VPWR VPWR _0234_ sky130_fd_sc_hd__a22o_1
XFILLER_66_174 VPWR VGND VPWR VGND sky130_ef_sc_hd__decap_12
XFILLER_54_358 VGND VGND VPWR VPWR sky130_fd_sc_hd__decap_6
XFILLER_54_347 VGND VGND VPWR VPWR sky130_fd_sc_hd__decap_4
XFILLER_22_211 VGND VGND VPWR VPWR sky130_fd_sc_hd__fill_2
XFILLER_13_69 VPWR VGND VPWR VGND sky130_ef_sc_hd__decap_12
XFILLER_1_137 VPWR VGND VPWR VGND sky130_ef_sc_hd__decap_12
XTAP_TAPCELL_ROW_9_237 VGND VPWR sky130_fd_sc_hd__tapvpwrvgnd_1
XFILLER_72_133 VGND VGND VPWR VPWR sky130_fd_sc_hd__decap_6
XFILLER_57_185 VGND VGND VPWR VPWR sky130_fd_sc_hd__fill_1
XFILLER_45_358 VGND VGND VPWR VPWR sky130_fd_sc_hd__decap_8
XFILLER_72_177 VPWR VGND VPWR VGND sky130_ef_sc_hd__decap_12
XFILLER_70_53 VPWR VGND VPWR VGND sky130_ef_sc_hd__decap_12
XFILLER_53_391 VGND VGND VPWR VPWR sky130_fd_sc_hd__fill_1
XTAP_TAPCELL_ROW_51_570 VGND VPWR sky130_fd_sc_hd__tapvpwrvgnd_1
XTAP_TAPCELL_ROW_43_504 VGND VPWR sky130_fd_sc_hd__tapvpwrvgnd_1
XFILLER_70_97 VPWR VGND VPWR VGND sky130_ef_sc_hd__decap_12
Xclkload18 clknet_leaf_21_clock VGND VGND VPWR VPWR clkload18/Y sky130_fd_sc_hd__bufinv_16
X_1280_ net30 net166 _0318_ VGND VGND VPWR VPWR _0146_ sky130_fd_sc_hd__a21bo_1
XFILLER_48_141 VGND VGND VPWR VPWR sky130_fd_sc_hd__decap_4
XFILLER_0_192 VGND VGND VPWR VPWR sky130_fd_sc_hd__decap_4
XFILLER_44_380 VPWR VGND VPWR VGND sky130_ef_sc_hd__decap_12
XFILLER_36_325 VPWR VGND VPWR VGND sky130_ef_sc_hd__decap_12
XFILLER_36_303 VGND VGND VPWR VPWR sky130_fd_sc_hd__decap_4
XTAP_TAPCELL_ROW_14_272 VGND VPWR sky130_fd_sc_hd__tapvpwrvgnd_1
X_0995_ scratch\[0\]\[25\] net226 _0731_ VGND VGND VPWR VPWR _0732_ sky130_fd_sc_hd__a21o_1
X_1547_ net304 net107 _0487_ VGND VGND VPWR VPWR _0244_ sky130_fd_sc_hd__a21o_1
X_1616_ net37 _0542_ net141 VGND VGND VPWR VPWR _0543_ sky130_fd_sc_hd__mux2_1
Xfanout227 net230 VGND VGND VPWR VPWR net227 sky130_fd_sc_hd__dlymetal6s2s_1
Xfanout205 _0333_ VGND VGND VPWR VPWR net205 sky130_fd_sc_hd__clkbuf_2
Xfanout238 net239 VGND VGND VPWR VPWR net238 sky130_fd_sc_hd__buf_1
Xfanout216 _0588_ VGND VGND VPWR VPWR net216 sky130_fd_sc_hd__clkbuf_2
XFILLER_5_81 VPWR VGND VPWR VGND sky130_ef_sc_hd__decap_12
X_1478_ net27 net143 net113 net433 VGND VGND VPWR VPWR _0217_ sky130_fd_sc_hd__a22o_1
XTAP_TAPCELL_ROW_57_618 VGND VPWR sky130_fd_sc_hd__tapvpwrvgnd_1
XFILLER_27_314 VGND VGND VPWR VPWR sky130_fd_sc_hd__fill_1
Xfanout249 net252 VGND VGND VPWR VPWR net249 sky130_fd_sc_hd__clkbuf_4
XTAP_TAPCELL_ROW_65_684 VGND VPWR sky130_fd_sc_hd__tapvpwrvgnd_1
XFILLER_50_383 VGND VGND VPWR VPWR sky130_fd_sc_hd__decap_8
XFILLER_40_89 VGND VGND VPWR VPWR sky130_fd_sc_hd__fill_1
XFILLER_40_67 VGND VGND VPWR VPWR sky130_fd_sc_hd__fill_1
XFILLER_2_413 VGND VGND VPWR VPWR sky130_fd_sc_hd__decap_6
XFILLER_49_98 VGND VGND VPWR VPWR sky130_fd_sc_hd__fill_1
XTAP_TAPCELL_ROW_28_386 VGND VPWR sky130_fd_sc_hd__tapvpwrvgnd_1
XFILLER_1_39 VPWR VGND VPWR VGND sky130_ef_sc_hd__decap_12
XFILLER_41_383 VGND VGND VPWR VPWR sky130_fd_sc_hd__decap_8
XTAP_TAPCELL_ROW_11_253 VGND VPWR sky130_fd_sc_hd__tapvpwrvgnd_1
XFILLER_53_6 VPWR VGND VPWR VGND sky130_ef_sc_hd__decap_12
X_1401_ _0358_ _0397_ _0398_ VGND VGND VPWR VPWR _0399_ sky130_fd_sc_hd__or3_1
XFILLER_5_273 VGND VGND VPWR VPWR sky130_fd_sc_hd__decap_6
X_1263_ net240 net162 scratch\[7\]\[9\] VGND VGND VPWR VPWR _0310_ sky130_fd_sc_hd__or3b_1
XFILLER_68_236 VGND VGND VPWR VPWR sky130_fd_sc_hd__decap_4
X_1194_ net241 net171 scratch\[6\]\[7\] VGND VGND VPWR VPWR _0275_ sky130_fd_sc_hd__or3b_1
Xinput5 host_input_addr[13] VGND VGND VPWR VPWR net5 sky130_fd_sc_hd__buf_1
X_1332_ _0777_ _0345_ VGND VGND VPWR VPWR _0346_ sky130_fd_sc_hd__and2_1
XFILLER_51_169 VGND VGND VPWR VPWR sky130_fd_sc_hd__decap_3
XFILLER_51_125 VPWR VGND VPWR VGND sky130_ef_sc_hd__decap_12
X_0978_ scratch\[0\]\[22\] net228 _0717_ VGND VGND VPWR VPWR _0718_ sky130_fd_sc_hd__a21o_1
XFILLER_10_26 VGND VGND VPWR VPWR sky130_fd_sc_hd__fill_2
XFILLER_59_225 VGND VGND VPWR VPWR sky130_fd_sc_hd__fill_2
XFILLER_70_445 VGND VGND VPWR VPWR sky130_fd_sc_hd__decap_8
XFILLER_70_401 VPWR VGND VPWR VGND sky130_ef_sc_hd__decap_12
XFILLER_42_103 VGND VGND VPWR VPWR sky130_fd_sc_hd__fill_1
XFILLER_15_317 VGND VGND VPWR VPWR sky130_fd_sc_hd__fill_2
XFILLER_19_57 VPWR VGND VPWR VGND sky130_ef_sc_hd__decap_12
XFILLER_19_79 VPWR VGND VPWR VGND sky130_ef_sc_hd__decap_12
XFILLER_30_309 VPWR VGND VPWR VGND sky130_ef_sc_hd__decap_12
XTAP_TAPCELL_ROW_25_367 VGND VPWR sky130_fd_sc_hd__tapvpwrvgnd_1
XFILLER_2_265 VPWR VGND VPWR VGND sky130_ef_sc_hd__decap_12
XFILLER_2_221 VPWR VGND VPWR VGND sky130_ef_sc_hd__decap_12
XFILLER_73_261 VPWR VGND VPWR VGND sky130_ef_sc_hd__decap_12
XFILLER_33_169 VPWR VGND VPWR VGND sky130_ef_sc_hd__decap_12
X_0901_ net207 _0650_ _0653_ VGND VGND VPWR VPWR net106 sky130_fd_sc_hd__and3_1
X_1881_ clknet_leaf_13_clock _0223_ VGND VGND VPWR VPWR scratch\[3\]\[20\] sky130_fd_sc_hd__dfxtp_1
X_0832_ net59 _0592_ _0593_ VGND VGND VPWR VPWR _0594_ sky130_fd_sc_hd__nor3_1
X_1315_ net71 _0336_ net205 VGND VGND VPWR VPWR _0337_ sky130_fd_sc_hd__a21boi_1
XTAP_TAPCELL_ROW_67_702 VGND VPWR sky130_fd_sc_hd__tapvpwrvgnd_1
X_1177_ net382 net125 _0811_ VGND VGND VPWR VPWR _0096_ sky130_fd_sc_hd__a21o_1
XFILLER_49_291 VGND VGND VPWR VPWR sky130_fd_sc_hd__fill_1
XFILLER_24_103 VGND VGND VPWR VPWR sky130_fd_sc_hd__decap_4
X_1246_ net22 net160 _0301_ VGND VGND VPWR VPWR _0129_ sky130_fd_sc_hd__a21bo_1
XFILLER_52_445 VGND VGND VPWR VPWR sky130_fd_sc_hd__decap_4
XFILLER_12_309 VPWR VGND VPWR VGND sky130_ef_sc_hd__decap_12
XFILLER_20_353 VGND VGND VPWR VPWR sky130_fd_sc_hd__decap_8
XTAP_TAPCELL_ROW_22_337 VGND VPWR sky130_fd_sc_hd__tapvpwrvgnd_1
XFILLER_21_69 VGND VGND VPWR VPWR sky130_fd_sc_hd__fill_1
XTAP_TAPCELL_ROW_73_749 VGND VPWR sky130_fd_sc_hd__tapvpwrvgnd_1
XFILLER_70_253 VPWR VGND VPWR VGND sky130_ef_sc_hd__decap_12
XFILLER_55_272 VGND VGND VPWR VPWR sky130_fd_sc_hd__decap_8
Xclkbuf_leaf_3_clock clknet_2_1__leaf_clock VGND VGND VPWR VPWR clknet_leaf_3_clock
+ sky130_fd_sc_hd__clkbuf_8
XTAP_TAPCELL_ROW_38_470 VGND VPWR sky130_fd_sc_hd__tapvpwrvgnd_1
XFILLER_15_169 VGND VGND VPWR VPWR sky130_fd_sc_hd__decap_6
XFILLER_7_335 VGND VGND VPWR VPWR sky130_fd_sc_hd__fill_1
X_1100_ net23 net185 net128 net366 VGND VGND VPWR VPWR _0043_ sky130_fd_sc_hd__a22o_1
X_1031_ scratch\[1\]\[31\] net213 _0761_ VGND VGND VPWR VPWR _0762_ sky130_fd_sc_hd__a21o_1
XFILLER_61_264 VGND VGND VPWR VPWR sky130_fd_sc_hd__fill_1
Xinput30 host_input_data[17] VGND VGND VPWR VPWR net30 sky130_fd_sc_hd__clkbuf_2
Xinput52 host_input_data[8] VGND VGND VPWR VPWR net52 sky130_fd_sc_hd__buf_2
X_1795_ clknet_leaf_7_clock _0138_ VGND VGND VPWR VPWR scratch\[7\]\[9\] sky130_fd_sc_hd__dfxtp_1
X_1864_ clknet_leaf_24_clock _0206_ VGND VGND VPWR VPWR scratch\[3\]\[3\] sky130_fd_sc_hd__dfxtp_1
X_0815_ net1 VGND VGND VPWR VPWR _0578_ sky130_fd_sc_hd__inv_2
Xinput41 host_input_data[27] VGND VGND VPWR VPWR net41 sky130_fd_sc_hd__clkbuf_2
Xinput63 host_output_addr[7] VGND VGND VPWR VPWR net63 sky130_fd_sc_hd__clkbuf_1
XFILLER_52_253 VPWR VGND VPWR VGND sky130_ef_sc_hd__decap_12
XFILLER_52_231 VPWR VGND VPWR VGND sky130_ef_sc_hd__decap_12
XTAP_TAPCELL_ROW_35_440 VGND VPWR sky130_fd_sc_hd__tapvpwrvgnd_1
X_1229_ net38 net174 _0292_ VGND VGND VPWR VPWR _0121_ sky130_fd_sc_hd__a21bo_1
XFILLER_75_312 VGND VGND VPWR VPWR sky130_fd_sc_hd__fill_2
XFILLER_43_275 VGND VGND VPWR VPWR sky130_fd_sc_hd__fill_1
X_1580_ net200 _0512_ _0513_ VGND VGND VPWR VPWR _0514_ sky130_fd_sc_hd__and3_1
XFILLER_11_183 VGND VGND VPWR VPWR sky130_fd_sc_hd__fill_2
XFILLER_3_393 VPWR VGND VPWR VGND sky130_ef_sc_hd__decap_12
XTAP_TAPCELL_ROW_49_554 VGND VPWR sky130_fd_sc_hd__tapvpwrvgnd_1
X_1014_ scratch\[4\]\[28\] net226 net217 scratch\[5\]\[28\] net234 VGND VGND VPWR
+ VPWR _0748_ sky130_fd_sc_hd__a221o_1
X_1916_ clknet_leaf_14_clock _0258_ VGND VGND VPWR VPWR scratch\[1\]\[23\] sky130_fd_sc_hd__dfxtp_1
X_1847_ clknet_leaf_15_clock _0189_ VGND VGND VPWR VPWR scratch\[0\]\[18\] sky130_fd_sc_hd__dfxtp_1
XTAP_TAPCELL_ROW_32_421 VGND VPWR sky130_fd_sc_hd__tapvpwrvgnd_1
XFILLER_22_448 VGND VGND VPWR VPWR sky130_fd_sc_hd__decap_4
X_1778_ clknet_leaf_21_clock _0121_ VGND VGND VPWR VPWR scratch\[6\]\[24\] sky130_fd_sc_hd__dfxtp_1
XFILLER_69_161 VGND VGND VPWR VPWR sky130_fd_sc_hd__decap_6
XFILLER_27_24 VGND VGND VPWR VPWR sky130_fd_sc_hd__decap_8
XFILLER_43_78 VPWR VGND VPWR VGND sky130_ef_sc_hd__decap_12
XFILLER_68_97 VPWR VGND VPWR VGND sky130_ef_sc_hd__decap_12
XFILLER_68_53 VPWR VGND VPWR VGND sky130_ef_sc_hd__decap_12
XFILLER_0_341 VPWR VGND VPWR VGND sky130_ef_sc_hd__decap_12
Xclkbuf_leaf_21_clock clknet_2_2__leaf_clock VGND VGND VPWR VPWR clknet_leaf_21_clock
+ sky130_fd_sc_hd__clkbuf_8
XFILLER_75_164 VGND VGND VPWR VPWR sky130_fd_sc_hd__decap_4
XTAP_TAPCELL_ROW_46_535 VGND VPWR sky130_fd_sc_hd__tapvpwrvgnd_1
XTAP_TAPCELL_ROW_3_190 VGND VPWR sky130_fd_sc_hd__tapvpwrvgnd_1
XFILLER_16_253 VGND VGND VPWR VPWR sky130_fd_sc_hd__fill_1
X_1701_ clknet_leaf_9_clock _0044_ VGND VGND VPWR VPWR scratch\[5\]\[11\] sky130_fd_sc_hd__dfxtp_1
XFILLER_16_286 VPWR VGND VPWR VGND sky130_ef_sc_hd__decap_12
X_1563_ scratch\[3\]\[13\] scratch\[2\]\[13\] VGND VGND VPWR VPWR _0500_ sky130_fd_sc_hd__nand2_1
X_1494_ net45 net143 net112 net393 VGND VGND VPWR VPWR _0233_ sky130_fd_sc_hd__a22o_1
X_1632_ net281 net109 _0555_ VGND VGND VPWR VPWR _0261_ sky130_fd_sc_hd__a21o_1
XFILLER_66_186 VGND VGND VPWR VPWR sky130_fd_sc_hd__decap_3
XFILLER_62_381 VPWR VGND VPWR VGND sky130_ef_sc_hd__decap_12
XFILLER_1_105 VGND VGND VPWR VPWR sky130_fd_sc_hd__decap_6
XFILLER_1_149 VPWR VGND VPWR VGND sky130_ef_sc_hd__decap_12
XTAP_TAPCELL_ROW_9_238 VGND VPWR sky130_fd_sc_hd__tapvpwrvgnd_1
XFILLER_72_189 VGND VGND VPWR VPWR sky130_fd_sc_hd__decap_6
XFILLER_60_307 VGND VGND VPWR VPWR sky130_fd_sc_hd__fill_1
XFILLER_45_326 VGND VGND VPWR VPWR sky130_fd_sc_hd__fill_1
XTAP_TAPCELL_ROW_43_505 VGND VPWR sky130_fd_sc_hd__tapvpwrvgnd_1
XFILLER_38_89 VPWR VGND VPWR VGND sky130_ef_sc_hd__decap_12
XTAP_TAPCELL_ROW_0_160 VGND VPWR sky130_fd_sc_hd__tapvpwrvgnd_1
XFILLER_70_65 VPWR VGND VPWR VGND sky130_ef_sc_hd__decap_12
XTAP_TAPCELL_ROW_51_571 VGND VPWR sky130_fd_sc_hd__tapvpwrvgnd_1
XFILLER_13_267 VGND VGND VPWR VPWR sky130_fd_sc_hd__fill_2
Xclkload19 clknet_leaf_22_clock VGND VGND VPWR VPWR clkload19/Y sky130_fd_sc_hd__clkinv_2
XFILLER_48_131 VGND VGND VPWR VPWR sky130_fd_sc_hd__decap_8
XFILLER_44_392 VGND VGND VPWR VPWR sky130_fd_sc_hd__fill_2
XFILLER_36_337 VGND VGND VPWR VPWR sky130_fd_sc_hd__fill_1
XTAP_TAPCELL_ROW_14_273 VGND VPWR sky130_fd_sc_hd__tapvpwrvgnd_1
X_0994_ scratch\[1\]\[25\] net218 _0730_ net259 net250 VGND VGND VPWR VPWR _0731_
+ sky130_fd_sc_hd__a221o_1
X_1546_ net53 _0486_ net138 VGND VGND VPWR VPWR _0487_ sky130_fd_sc_hd__mux2_1
Xfanout228 net230 VGND VGND VPWR VPWR net228 sky130_fd_sc_hd__buf_2
X_1615_ net199 _0540_ _0541_ VGND VGND VPWR VPWR _0542_ sky130_fd_sc_hd__and3_1
X_1477_ net26 net144 net114 net425 VGND VGND VPWR VPWR _0216_ sky130_fd_sc_hd__a22o_1
Xfanout217 net221 VGND VGND VPWR VPWR net217 sky130_fd_sc_hd__buf_2
XFILLER_5_93 VPWR VGND VPWR VGND sky130_ef_sc_hd__decap_12
XTAP_TAPCELL_ROW_6_208 VGND VPWR sky130_fd_sc_hd__tapvpwrvgnd_1
Xfanout239 net242 VGND VGND VPWR VPWR net239 sky130_fd_sc_hd__clkbuf_2
Xfanout206 net210 VGND VGND VPWR VPWR net206 sky130_fd_sc_hd__buf_2
XTAP_TAPCELL_ROW_57_619 VGND VPWR sky130_fd_sc_hd__tapvpwrvgnd_1
XFILLER_42_307 VGND VGND VPWR VPWR sky130_fd_sc_hd__fill_1
XFILLER_27_337 VGND VGND VPWR VPWR sky130_fd_sc_hd__fill_1
XTAP_TAPCELL_ROW_65_685 VGND VPWR sky130_fd_sc_hd__tapvpwrvgnd_1
XFILLER_10_226 VPWR VGND VPWR VGND sky130_ef_sc_hd__decap_12
XPHY_EDGE_ROW_17_Left_93 VGND VGND VPWR VPWR sky130_fd_sc_hd__decap_3
XFILLER_49_66 VGND VGND VPWR VPWR sky130_fd_sc_hd__decap_4
XFILLER_49_55 VGND VGND VPWR VPWR sky130_fd_sc_hd__fill_1
XTAP_TAPCELL_ROW_28_387 VGND VPWR sky130_fd_sc_hd__tapvpwrvgnd_1
XTAP_TAPCELL_ROW_11_254 VGND VPWR sky130_fd_sc_hd__tapvpwrvgnd_1
XFILLER_14_80 VGND VGND VPWR VPWR sky130_fd_sc_hd__decap_4
X_1400_ scratch\[0\]\[16\] net150 _0393_ VGND VGND VPWR VPWR _0398_ sky130_fd_sc_hd__and3_1
X_1331_ net1 _0768_ VGND VGND VPWR VPWR _0345_ sky130_fd_sc_hd__nor2_1
Xinput6 host_input_addr[14] VGND VGND VPWR VPWR net6 sky130_fd_sc_hd__clkbuf_1
XFILLER_64_421 VPWR VGND VPWR VGND sky130_ef_sc_hd__decap_12
X_1262_ net52 net161 _0309_ VGND VGND VPWR VPWR _0137_ sky130_fd_sc_hd__a21bo_1
X_1193_ net50 net171 _0274_ VGND VGND VPWR VPWR _0103_ sky130_fd_sc_hd__a21bo_1
XFILLER_51_137 VGND VGND VPWR VPWR sky130_fd_sc_hd__decap_3
XFILLER_32_395 VPWR VGND VPWR VGND sky130_ef_sc_hd__decap_12
X_0977_ scratch\[1\]\[22\] net217 _0716_ net258 net250 VGND VGND VPWR VPWR _0717_
+ sky130_fd_sc_hd__a221o_1
X_1529_ scratch\[3\]\[6\] scratch\[2\]\[6\] VGND VGND VPWR VPWR _0473_ sky130_fd_sc_hd__or2_1
XFILLER_19_69 VGND VGND VPWR VPWR sky130_fd_sc_hd__decap_4
XFILLER_70_413 VGND VGND VPWR VPWR sky130_fd_sc_hd__decap_6
XFILLER_35_57 VGND VGND VPWR VPWR sky130_fd_sc_hd__decap_6
XFILLER_35_46 VGND VGND VPWR VPWR sky130_fd_sc_hd__decap_8
XFILLER_35_35 VGND VGND VPWR VPWR sky130_fd_sc_hd__decap_3
XPHY_EDGE_ROW_2_Left_78 VGND VGND VPWR VPWR sky130_fd_sc_hd__decap_3
XPHY_EDGE_ROW_14_Right_14 VGND VGND VPWR VPWR sky130_fd_sc_hd__decap_3
XPHY_EDGE_ROW_23_Right_23 VGND VGND VPWR VPWR sky130_fd_sc_hd__decap_3
XFILLER_2_277 VPWR VGND VPWR VGND sky130_ef_sc_hd__decap_12
XFILLER_2_233 VPWR VGND VPWR VGND sky130_ef_sc_hd__decap_12
XFILLER_46_421 VGND VGND VPWR VPWR sky130_fd_sc_hd__decap_8
XFILLER_73_273 VGND VGND VPWR VPWR sky130_fd_sc_hd__decap_6
X_1880_ clknet_leaf_12_clock _0222_ VGND VGND VPWR VPWR scratch\[3\]\[19\] sky130_fd_sc_hd__dfxtp_1
X_0900_ net256 _0651_ _0652_ VGND VGND VPWR VPWR _0653_ sky130_fd_sc_hd__a21o_1
XFILLER_33_148 VGND VGND VPWR VPWR sky130_fd_sc_hd__fill_2
XPHY_EDGE_ROW_32_Right_32 VGND VGND VPWR VPWR sky130_fd_sc_hd__decap_3
XFILLER_18_189 VGND VGND VPWR VPWR sky130_fd_sc_hd__decap_6
X_0831_ net60 net62 net61 net63 VGND VGND VPWR VPWR _0593_ sky130_fd_sc_hd__or4_1
XTAP_TAPCELL_ROW_67_703 VGND VPWR sky130_fd_sc_hd__tapvpwrvgnd_1
XFILLER_44_3 VGND VGND VPWR VPWR sky130_fd_sc_hd__decap_8
XPHY_EDGE_ROW_41_Right_41 VGND VGND VPWR VPWR sky130_fd_sc_hd__decap_3
X_1314_ _0336_ net205 _0335_ VGND VGND VPWR VPWR _0162_ sky130_fd_sc_hd__and3b_1
X_1176_ net13 net202 net183 net34 VGND VGND VPWR VPWR _0811_ sky130_fd_sc_hd__a22o_1
XPHY_EDGE_ROW_50_Right_50 VGND VGND VPWR VPWR sky130_fd_sc_hd__decap_3
XFILLER_49_281 VGND VGND VPWR VPWR sky130_fd_sc_hd__fill_1
XFILLER_24_115 VPWR VGND VPWR VGND sky130_ef_sc_hd__decap_12
XFILLER_2_83 VGND VGND VPWR VPWR sky130_fd_sc_hd__fill_1
X_1245_ net237 net160 scratch\[7\]\[0\] VGND VGND VPWR VPWR _0301_ sky130_fd_sc_hd__or3b_1
XPHY_EDGE_ROW_25_Left_101 VGND VGND VPWR VPWR sky130_fd_sc_hd__decap_3
XFILLER_20_321 VPWR VGND VPWR VGND sky130_ef_sc_hd__decap_12
XFILLER_20_365 VGND VGND VPWR VPWR sky130_fd_sc_hd__decap_6
XFILLER_21_37 VGND VGND VPWR VPWR sky130_fd_sc_hd__decap_3
XTAP_TAPCELL_ROW_22_338 VGND VPWR sky130_fd_sc_hd__tapvpwrvgnd_1
XPHY_EDGE_ROW_34_Left_110 VGND VGND VPWR VPWR sky130_fd_sc_hd__decap_3
XFILLER_28_421 VGND VGND VPWR VPWR sky130_fd_sc_hd__decap_6
XFILLER_70_265 VPWR VGND VPWR VGND sky130_ef_sc_hd__decap_12
XFILLER_70_221 VPWR VGND VPWR VGND sky130_ef_sc_hd__decap_12
XTAP_TAPCELL_ROW_38_471 VGND VPWR sky130_fd_sc_hd__tapvpwrvgnd_1
XFILLER_46_251 VGND VGND VPWR VPWR sky130_fd_sc_hd__fill_1
X_1030_ scratch\[0\]\[31\] net225 _0760_ net253 net249 VGND VGND VPWR VPWR _0761_
+ sky130_fd_sc_hd__a221o_1
Xinput20 host_input_addr[8] VGND VGND VPWR VPWR net20 sky130_fd_sc_hd__buf_1
X_0814_ cycle_count\[2\] VGND VGND VPWR VPWR _0577_ sky130_fd_sc_hd__inv_2
Xinput31 host_input_data[18] VGND VGND VPWR VPWR net31 sky130_fd_sc_hd__clkbuf_2
X_1863_ clknet_leaf_28_clock _0205_ VGND VGND VPWR VPWR scratch\[3\]\[2\] sky130_fd_sc_hd__dfxtp_1
Xinput53 host_input_data[9] VGND VGND VPWR VPWR net53 sky130_fd_sc_hd__clkbuf_2
X_1794_ clknet_leaf_6_clock _0137_ VGND VGND VPWR VPWR scratch\[7\]\[8\] sky130_fd_sc_hd__dfxtp_1
Xinput42 host_input_data[28] VGND VGND VPWR VPWR net42 sky130_fd_sc_hd__buf_2
Xinput64 host_output_addr[8] VGND VGND VPWR VPWR net64 sky130_fd_sc_hd__clkbuf_1
X_1228_ net244 net174 scratch\[6\]\[24\] VGND VGND VPWR VPWR _0292_ sky130_fd_sc_hd__or3b_1
X_1159_ net374 net125 _0802_ VGND VGND VPWR VPWR _0087_ sky130_fd_sc_hd__a21o_1
XFILLER_52_265 VPWR VGND VPWR VGND sky130_ef_sc_hd__decap_12
XFILLER_52_243 VGND VGND VPWR VPWR sky130_fd_sc_hd__decap_8
XTAP_TAPCELL_ROW_35_441 VGND VPWR sky130_fd_sc_hd__tapvpwrvgnd_1
XFILLER_25_435 VPWR VGND VPWR VGND sky130_ef_sc_hd__decap_12
XFILLER_57_33 VGND VGND VPWR VPWR sky130_fd_sc_hd__decap_4
XFILLER_75_335 VGND VGND VPWR VPWR sky130_fd_sc_hd__fill_1
XFILLER_43_210 VGND VGND VPWR VPWR sky130_fd_sc_hd__fill_2
XFILLER_28_273 VGND VGND VPWR VPWR sky130_fd_sc_hd__fill_2
XFILLER_28_251 VGND VGND VPWR VPWR sky130_fd_sc_hd__fill_1
XTAP_TAPCELL_ROW_41_488 VGND VPWR sky130_fd_sc_hd__tapvpwrvgnd_1
XFILLER_7_111 VGND VGND VPWR VPWR sky130_fd_sc_hd__fill_1
XPHY_EDGE_ROW_5_Left_81 VGND VGND VPWR VPWR sky130_fd_sc_hd__decap_3
XFILLER_3_361 VPWR VGND VPWR VGND sky130_ef_sc_hd__decap_12
XFILLER_66_346 VGND VGND VPWR VPWR sky130_fd_sc_hd__fill_2
XTAP_TAPCELL_ROW_49_555 VGND VPWR sky130_fd_sc_hd__tapvpwrvgnd_1
XFILLER_19_240 VPWR VGND VPWR VGND sky130_ef_sc_hd__decap_12
XTAP_TAPCELL_ROW_32_422 VGND VPWR sky130_fd_sc_hd__tapvpwrvgnd_1
X_1013_ scratch\[6\]\[28\] scratch\[7\]\[28\] net268 VGND VGND VPWR VPWR _0747_ sky130_fd_sc_hd__mux2_1
X_1846_ clknet_leaf_15_clock _0188_ VGND VGND VPWR VPWR scratch\[0\]\[17\] sky130_fd_sc_hd__dfxtp_1
X_1777_ clknet_leaf_14_clock _0120_ VGND VGND VPWR VPWR scratch\[6\]\[23\] sky130_fd_sc_hd__dfxtp_1
X_1915_ clknet_leaf_16_clock _0257_ VGND VGND VPWR VPWR scratch\[1\]\[22\] sky130_fd_sc_hd__dfxtp_1
XFILLER_57_302 VPWR VGND VPWR VGND sky130_ef_sc_hd__decap_12
Xclkbuf_leaf_2_clock clknet_2_1__leaf_clock VGND VGND VPWR VPWR clknet_leaf_2_clock
+ sky130_fd_sc_hd__clkbuf_8
XPHY_EDGE_ROW_4_Right_4 VGND VGND VPWR VPWR sky130_fd_sc_hd__decap_3
XFILLER_43_46 VGND VGND VPWR VPWR sky130_fd_sc_hd__decap_8
XFILLER_40_213 VGND VGND VPWR VPWR sky130_fd_sc_hd__decap_4
XFILLER_25_276 VGND VGND VPWR VPWR sky130_fd_sc_hd__decap_4
XFILLER_13_405 VGND VGND VPWR VPWR sky130_fd_sc_hd__decap_6
XFILLER_13_449 VGND VGND VPWR VPWR sky130_fd_sc_hd__fill_1
XFILLER_4_29 VPWR VGND VPWR VGND sky130_ef_sc_hd__decap_12
XFILLER_68_65 VPWR VGND VPWR VGND sky130_ef_sc_hd__decap_12
XFILLER_0_353 VGND VGND VPWR VPWR sky130_fd_sc_hd__decap_8
XFILLER_71_393 VPWR VGND VPWR VGND sky130_ef_sc_hd__decap_12
XFILLER_56_390 VGND VGND VPWR VPWR sky130_fd_sc_hd__decap_4
XTAP_TAPCELL_ROW_3_191 VGND VPWR sky130_fd_sc_hd__tapvpwrvgnd_1
XFILLER_16_298 VGND VGND VPWR VPWR sky130_fd_sc_hd__decap_8
X_1700_ clknet_leaf_8_clock _0043_ VGND VGND VPWR VPWR scratch\[5\]\[10\] sky130_fd_sc_hd__dfxtp_1
X_1631_ net40 _0554_ net139 VGND VGND VPWR VPWR _0555_ sky130_fd_sc_hd__mux2_1
X_1562_ net290 net111 _0499_ VGND VGND VPWR VPWR _0247_ sky130_fd_sc_hd__a21o_1
X_1493_ net43 net144 net114 net417 VGND VGND VPWR VPWR _0232_ sky130_fd_sc_hd__a22o_1
XFILLER_66_165 VGND VGND VPWR VPWR sky130_fd_sc_hd__fill_2
XFILLER_66_121 VPWR VGND VPWR VGND sky130_ef_sc_hd__decap_12
XFILLER_47_390 VGND VGND VPWR VPWR sky130_fd_sc_hd__fill_2
XFILLER_62_393 VPWR VGND VPWR VGND sky130_ef_sc_hd__decap_12
XFILLER_10_419 VGND VGND VPWR VPWR sky130_fd_sc_hd__fill_1
X_1829_ clknet_leaf_25_clock _0171_ VGND VGND VPWR VPWR scratch\[0\]\[0\] sky130_fd_sc_hd__dfxtp_1
XTAP_TAPCELL_ROW_9_239 VGND VPWR sky130_fd_sc_hd__tapvpwrvgnd_1
XFILLER_57_110 VGND VGND VPWR VPWR sky130_fd_sc_hd__fill_2
XFILLER_38_35 VPWR VGND VPWR VGND sky130_ef_sc_hd__decap_12
XFILLER_54_56 VPWR VGND VPWR VGND sky130_ef_sc_hd__decap_12
XFILLER_53_393 VGND VGND VPWR VPWR sky130_fd_sc_hd__decap_4
XTAP_TAPCELL_ROW_43_506 VGND VPWR sky130_fd_sc_hd__tapvpwrvgnd_1
XTAP_TAPCELL_ROW_0_161 VGND VPWR sky130_fd_sc_hd__tapvpwrvgnd_1
XFILLER_70_77 VGND VGND VPWR VPWR sky130_fd_sc_hd__decap_6
XTAP_TAPCELL_ROW_51_572 VGND VPWR sky130_fd_sc_hd__tapvpwrvgnd_1
XFILLER_9_217 VGND VGND VPWR VPWR sky130_fd_sc_hd__decap_6
XFILLER_13_235 VGND VGND VPWR VPWR sky130_fd_sc_hd__decap_4
XFILLER_68_419 VGND VGND VPWR VPWR sky130_fd_sc_hd__fill_1
XFILLER_0_150 VPWR VGND VPWR VGND sky130_ef_sc_hd__decap_12
X_0993_ scratch\[2\]\[25\] scratch\[3\]\[25\] net269 VGND VGND VPWR VPWR _0730_ sky130_fd_sc_hd__mux2_1
XFILLER_74_3 VPWR VGND VPWR VGND sky130_ef_sc_hd__decap_12
X_1614_ scratch\[3\]\[23\] scratch\[2\]\[23\] VGND VGND VPWR VPWR _0541_ sky130_fd_sc_hd__or2_1
XTAP_TAPCELL_ROW_14_274 VGND VPWR sky130_fd_sc_hd__tapvpwrvgnd_1
XFILLER_67_441 VGND VGND VPWR VPWR sky130_fd_sc_hd__decap_6
X_1476_ net25 net145 net115 net411 VGND VGND VPWR VPWR _0215_ sky130_fd_sc_hd__a22o_1
X_1545_ net201 _0484_ _0485_ VGND VGND VPWR VPWR _0486_ sky130_fd_sc_hd__and3_1
Xfanout207 net210 VGND VGND VPWR VPWR net207 sky130_fd_sc_hd__buf_2
Xfanout229 net230 VGND VGND VPWR VPWR net229 sky130_fd_sc_hd__clkbuf_2
Xfanout218 net221 VGND VGND VPWR VPWR net218 sky130_fd_sc_hd__clkbuf_2
XTAP_TAPCELL_ROW_6_209 VGND VPWR sky130_fd_sc_hd__tapvpwrvgnd_1
XTAP_TAPCELL_ROW_65_686 VGND VPWR sky130_fd_sc_hd__tapvpwrvgnd_1
XFILLER_50_374 VGND VGND VPWR VPWR sky130_fd_sc_hd__decap_4
XFILLER_50_363 VGND VGND VPWR VPWR sky130_fd_sc_hd__fill_1
XFILLER_24_59 VGND VGND VPWR VPWR sky130_fd_sc_hd__decap_4
XFILLER_6_209 VPWR VGND VPWR VGND sky130_ef_sc_hd__decap_12
XFILLER_10_238 VGND VGND VPWR VPWR sky130_fd_sc_hd__decap_8
Xclkbuf_leaf_20_clock clknet_2_2__leaf_clock VGND VGND VPWR VPWR clknet_leaf_20_clock
+ sky130_fd_sc_hd__clkbuf_8
XFILLER_6_6 VPWR VGND VPWR VGND sky130_ef_sc_hd__decap_12
XFILLER_65_55 VGND VGND VPWR VPWR sky130_fd_sc_hd__fill_1
XFILLER_49_78 VPWR VGND VPWR VGND sky130_ef_sc_hd__decap_12
XFILLER_33_319 VPWR VGND VPWR VGND sky130_ef_sc_hd__decap_12
XTAP_TAPCELL_ROW_28_388 VGND VPWR sky130_fd_sc_hd__tapvpwrvgnd_1
XFILLER_60_9 VPWR VGND VPWR VGND sky130_ef_sc_hd__decap_12
XTAP_TAPCELL_ROW_11_255 VGND VPWR sky130_fd_sc_hd__tapvpwrvgnd_1
XFILLER_68_249 VGND VGND VPWR VPWR sky130_fd_sc_hd__decap_3
X_1261_ net241 net161 scratch\[7\]\[8\] VGND VGND VPWR VPWR _0309_ sky130_fd_sc_hd__or3b_1
X_1330_ net212 net67 _0788_ VGND VGND VPWR VPWR _0170_ sky130_fd_sc_hd__o21ba_1
XFILLER_64_433 VPWR VGND VPWR VGND sky130_ef_sc_hd__decap_12
X_1192_ net241 net171 scratch\[6\]\[6\] VGND VGND VPWR VPWR _0274_ sky130_fd_sc_hd__or3b_1
Xinput7 host_input_addr[15] VGND VGND VPWR VPWR net7 sky130_fd_sc_hd__buf_1
XFILLER_36_135 VGND VGND VPWR VPWR sky130_fd_sc_hd__fill_1
XTAP_TAPCELL_ROW_62_656 VGND VPWR sky130_fd_sc_hd__tapvpwrvgnd_1
X_0976_ scratch\[2\]\[22\] scratch\[3\]\[22\] net268 VGND VGND VPWR VPWR _0716_ sky130_fd_sc_hd__mux2_1
XFILLER_32_341 VGND VGND VPWR VPWR sky130_fd_sc_hd__decap_4
X_1528_ scratch\[3\]\[6\] scratch\[2\]\[6\] VGND VGND VPWR VPWR _0472_ sky130_fd_sc_hd__nand2_1
X_1459_ net45 net155 _0440_ _0442_ VGND VGND VPWR VPWR _0201_ sky130_fd_sc_hd__a22o_1
XFILLER_42_138 VGND VGND VPWR VPWR sky130_fd_sc_hd__fill_2
XFILLER_35_190 VPWR VGND VPWR VGND sky130_ef_sc_hd__decap_12
XFILLER_35_69 VGND VGND VPWR VPWR sky130_fd_sc_hd__decap_8
XFILLER_4_3 VPWR VGND VPWR VGND sky130_ef_sc_hd__decap_12
XFILLER_2_289 VPWR VGND VPWR VGND sky130_ef_sc_hd__decap_12
XFILLER_2_245 VGND VGND VPWR VPWR sky130_fd_sc_hd__decap_6
XFILLER_33_127 VGND VGND VPWR VPWR sky130_fd_sc_hd__fill_1
XFILLER_18_157 VPWR VGND VPWR VGND sky130_ef_sc_hd__decap_12
XFILLER_61_447 VGND VGND VPWR VPWR sky130_fd_sc_hd__fill_1
XFILLER_25_91 VGND VGND VPWR VPWR sky130_fd_sc_hd__fill_1
X_0830_ net64 net56 net65 VGND VGND VPWR VPWR _0592_ sky130_fd_sc_hd__or3_1
XFILLER_56_208 VPWR VGND VPWR VGND sky130_ef_sc_hd__decap_12
X_1244_ _0786_ _0812_ VGND VGND VPWR VPWR _0300_ sky130_fd_sc_hd__nor2_1
X_1313_ net211 net70 net69 VGND VGND VPWR VPWR _0336_ sky130_fd_sc_hd__and3_1
XTAP_TAPCELL_ROW_75_770 VGND VPWR sky130_fd_sc_hd__tapvpwrvgnd_1
X_1175_ net386 net126 _0810_ VGND VGND VPWR VPWR _0095_ sky130_fd_sc_hd__a21o_1
XFILLER_52_414 VGND VGND VPWR VPWR sky130_fd_sc_hd__decap_6
XFILLER_24_127 VPWR VGND VPWR VGND sky130_ef_sc_hd__decap_12
X_0959_ scratch\[4\]\[19\] net229 net220 scratch\[5\]\[19\] net233 VGND VGND VPWR
+ VPWR _0702_ sky130_fd_sc_hd__a221o_1
XFILLER_32_171 VGND VGND VPWR VPWR sky130_fd_sc_hd__fill_2
XTAP_TAPCELL_ROW_22_339 VGND VPWR sky130_fd_sc_hd__tapvpwrvgnd_1
XFILLER_20_333 VGND VGND VPWR VPWR sky130_fd_sc_hd__decap_6
XFILLER_70_277 VPWR VGND VPWR VGND sky130_ef_sc_hd__decap_12
XFILLER_70_233 VPWR VGND VPWR VGND sky130_ef_sc_hd__decap_12
XFILLER_7_18 VPWR VGND VPWR VGND sky130_ef_sc_hd__decap_12
XFILLER_15_149 VGND VGND VPWR VPWR sky130_fd_sc_hd__decap_3
XFILLER_7_337 VPWR VGND VPWR VGND sky130_ef_sc_hd__decap_12
XFILLER_23_9 VPWR VGND VPWR VGND sky130_ef_sc_hd__decap_12
XFILLER_19_433 VPWR VGND VPWR VGND sky130_ef_sc_hd__decap_12
XTAP_TAPCELL_ROW_72_740 VGND VPWR sky130_fd_sc_hd__tapvpwrvgnd_1
XFILLER_21_108 VGND VGND VPWR VPWR sky130_fd_sc_hd__decap_4
Xinput32 host_input_data[19] VGND VGND VPWR VPWR net32 sky130_fd_sc_hd__buf_2
Xinput54 host_input_we VGND VGND VPWR VPWR net54 sky130_fd_sc_hd__clkbuf_1
Xinput21 host_input_addr[9] VGND VGND VPWR VPWR net21 sky130_fd_sc_hd__clkbuf_1
X_1793_ clknet_leaf_5_clock _0136_ VGND VGND VPWR VPWR scratch\[7\]\[7\] sky130_fd_sc_hd__dfxtp_1
Xinput10 host_input_addr[18] VGND VGND VPWR VPWR net10 sky130_fd_sc_hd__buf_1
X_0813_ net211 VGND VGND VPWR VPWR _0576_ sky130_fd_sc_hd__inv_2
Xinput43 host_input_data[29] VGND VGND VPWR VPWR net43 sky130_fd_sc_hd__buf_2
X_1862_ clknet_leaf_27_clock _0204_ VGND VGND VPWR VPWR scratch\[3\]\[1\] sky130_fd_sc_hd__dfxtp_1
Xinput65 host_output_addr[9] VGND VGND VPWR VPWR net65 sky130_fd_sc_hd__clkbuf_1
X_1158_ net3 net201 net183 net24 VGND VGND VPWR VPWR _0802_ sky130_fd_sc_hd__a22o_1
X_1227_ net37 net176 _0291_ VGND VGND VPWR VPWR _0120_ sky130_fd_sc_hd__a21bo_1
XFILLER_25_425 VGND VGND VPWR VPWR sky130_fd_sc_hd__fill_2
XFILLER_52_277 VPWR VGND VPWR VGND sky130_ef_sc_hd__decap_12
XTAP_TAPCELL_ROW_35_442 VGND VPWR sky130_fd_sc_hd__tapvpwrvgnd_1
X_1089_ net238 net184 VGND VGND VPWR VPWR _0787_ sky130_fd_sc_hd__nor2_1
XFILLER_32_26 VGND VGND VPWR VPWR sky130_fd_sc_hd__fill_2
XFILLER_25_447 VGND VGND VPWR VPWR sky130_fd_sc_hd__fill_1
XFILLER_20_130 VGND VGND VPWR VPWR sky130_fd_sc_hd__decap_4
XFILLER_20_141 VGND VGND VPWR VPWR sky130_fd_sc_hd__decap_4
XFILLER_4_307 VGND VGND VPWR VPWR sky130_fd_sc_hd__fill_1
XFILLER_75_325 VGND VGND VPWR VPWR sky130_fd_sc_hd__decap_3
XFILLER_75_369 VGND VGND VPWR VPWR sky130_fd_sc_hd__fill_1
XFILLER_73_55 VGND VGND VPWR VPWR sky130_fd_sc_hd__fill_1
XTAP_TAPCELL_ROW_41_489 VGND VPWR sky130_fd_sc_hd__tapvpwrvgnd_1
XFILLER_3_373 VPWR VGND VPWR VGND sky130_ef_sc_hd__decap_12
XFILLER_7_167 VGND VGND VPWR VPWR sky130_fd_sc_hd__fill_1
XPHY_EDGE_ROW_53_Left_129 VGND VGND VPWR VPWR sky130_fd_sc_hd__decap_3
XTAP_TAPCELL_ROW_49_556 VGND VPWR sky130_fd_sc_hd__tapvpwrvgnd_1
X_1012_ scratch\[0\]\[28\] net226 _0745_ VGND VGND VPWR VPWR _0746_ sky130_fd_sc_hd__a21o_1
XFILLER_19_252 VGND VGND VPWR VPWR sky130_fd_sc_hd__decap_8
X_1914_ clknet_leaf_13_clock _0256_ VGND VGND VPWR VPWR scratch\[1\]\[21\] sky130_fd_sc_hd__dfxtp_1
XFILLER_34_299 VGND VGND VPWR VPWR sky130_fd_sc_hd__decap_3
XFILLER_34_211 VGND VGND VPWR VPWR sky130_fd_sc_hd__fill_1
XTAP_TAPCELL_ROW_32_423 VGND VPWR sky130_fd_sc_hd__tapvpwrvgnd_1
XFILLER_22_439 VGND VGND VPWR VPWR sky130_fd_sc_hd__fill_1
XPHY_EDGE_ROW_62_Left_138 VGND VGND VPWR VPWR sky130_fd_sc_hd__decap_3
X_1845_ clknet_leaf_16_clock _0187_ VGND VGND VPWR VPWR scratch\[0\]\[16\] sky130_fd_sc_hd__dfxtp_1
X_1776_ clknet_leaf_18_clock _0119_ VGND VGND VPWR VPWR scratch\[6\]\[22\] sky130_fd_sc_hd__dfxtp_1
XFILLER_8_83 VGND VGND VPWR VPWR sky130_fd_sc_hd__fill_1
XPHY_EDGE_ROW_71_Left_147 VGND VGND VPWR VPWR sky130_fd_sc_hd__decap_3
XFILLER_57_314 VGND VGND VPWR VPWR sky130_fd_sc_hd__decap_6
XFILLER_65_391 VGND VGND VPWR VPWR sky130_fd_sc_hd__fill_1
XFILLER_57_347 VGND VGND VPWR VPWR sky130_fd_sc_hd__decap_6
XFILLER_13_439 VGND VGND VPWR VPWR sky130_fd_sc_hd__decap_8
XFILLER_68_77 VGND VGND VPWR VPWR sky130_fd_sc_hd__decap_6
XFILLER_0_365 VPWR VGND VPWR VGND sky130_ef_sc_hd__decap_12
XFILLER_71_361 VPWR VGND VPWR VGND sky130_ef_sc_hd__decap_12
XTAP_TAPCELL_ROW_54_592 VGND VPWR sky130_fd_sc_hd__tapvpwrvgnd_1
XFILLER_31_247 VGND VGND VPWR VPWR sky130_fd_sc_hd__fill_1
XFILLER_17_81 VGND VGND VPWR VPWR sky130_fd_sc_hd__decap_8
XFILLER_33_91 VGND VGND VPWR VPWR sky130_fd_sc_hd__fill_1
XFILLER_8_421 VPWR VGND VPWR VGND sky130_ef_sc_hd__decap_12
X_1630_ net199 _0552_ _0553_ VGND VGND VPWR VPWR _0554_ sky130_fd_sc_hd__and3_1
X_1561_ net25 _0498_ net140 VGND VGND VPWR VPWR _0499_ sky130_fd_sc_hd__mux2_1
X_1492_ net42 net144 net114 net415 VGND VGND VPWR VPWR _0231_ sky130_fd_sc_hd__a22o_1
XFILLER_3_181 VPWR VGND VPWR VGND sky130_ef_sc_hd__decap_12
XFILLER_66_133 VGND VGND VPWR VPWR sky130_fd_sc_hd__decap_6
XFILLER_54_306 VGND VGND VPWR VPWR sky130_fd_sc_hd__fill_2
XFILLER_22_269 VGND VGND VPWR VPWR sky130_fd_sc_hd__decap_8
X_1759_ clknet_leaf_4_clock _0102_ VGND VGND VPWR VPWR scratch\[6\]\[5\] sky130_fd_sc_hd__dfxtp_1
X_1828_ clknet_leaf_0_clock _0170_ VGND VGND VPWR VPWR net68 sky130_fd_sc_hd__dfxtp_1
XFILLER_57_166 VGND VGND VPWR VPWR sky130_fd_sc_hd__fill_2
XFILLER_54_68 VGND VGND VPWR VPWR sky130_fd_sc_hd__decap_6
XFILLER_53_361 VPWR VGND VPWR VGND sky130_ef_sc_hd__decap_12
XTAP_TAPCELL_ROW_43_507 VGND VPWR sky130_fd_sc_hd__tapvpwrvgnd_1
XTAP_TAPCELL_ROW_0_162 VGND VPWR sky130_fd_sc_hd__tapvpwrvgnd_1
XTAP_TAPCELL_ROW_51_573 VGND VPWR sky130_fd_sc_hd__tapvpwrvgnd_1
XFILLER_0_162 VGND VGND VPWR VPWR sky130_fd_sc_hd__decap_6
XFILLER_63_169 VGND VGND VPWR VPWR sky130_fd_sc_hd__fill_2
XFILLER_48_111 VGND VGND VPWR VPWR sky130_fd_sc_hd__decap_8
XFILLER_29_391 VGND VGND VPWR VPWR sky130_fd_sc_hd__fill_1
XFILLER_0_173 VGND VGND VPWR VPWR sky130_fd_sc_hd__fill_1
Xclkbuf_2_1__f_clock clknet_0_clock VGND VGND VPWR VPWR clknet_2_1__leaf_clock sky130_fd_sc_hd__clkbuf_16
Xclkbuf_leaf_1_clock clknet_2_0__leaf_clock VGND VGND VPWR VPWR clknet_leaf_1_clock
+ sky130_fd_sc_hd__clkbuf_8
XTAP_TAPCELL_ROW_14_275 VGND VPWR sky130_fd_sc_hd__tapvpwrvgnd_1
X_0992_ net250 _0726_ _0728_ _0729_ net208 VGND VGND VPWR VPWR net91 sky130_fd_sc_hd__o221a_1
XFILLER_67_3 VPWR VGND VPWR VGND sky130_ef_sc_hd__decap_12
X_1544_ scratch\[3\]\[9\] scratch\[2\]\[9\] VGND VGND VPWR VPWR _0485_ sky130_fd_sc_hd__or2_1
X_1613_ scratch\[3\]\[23\] scratch\[2\]\[23\] VGND VGND VPWR VPWR _0540_ sky130_fd_sc_hd__nand2_1
XFILLER_8_273 VPWR VGND VPWR VGND sky130_ef_sc_hd__decap_12
X_1475_ net24 net145 net115 net427 VGND VGND VPWR VPWR _0214_ sky130_fd_sc_hd__a22o_1
Xfanout219 net221 VGND VGND VPWR VPWR net219 sky130_fd_sc_hd__buf_2
XFILLER_39_166 VGND VGND VPWR VPWR sky130_fd_sc_hd__fill_2
Xfanout208 net209 VGND VGND VPWR VPWR net208 sky130_fd_sc_hd__buf_2
XTAP_TAPCELL_ROW_65_687 VGND VPWR sky130_fd_sc_hd__tapvpwrvgnd_1
XFILLER_42_309 VGND VGND VPWR VPWR sky130_fd_sc_hd__fill_1
XFILLER_35_350 VGND VGND VPWR VPWR sky130_fd_sc_hd__decap_4
XFILLER_24_38 VGND VGND VPWR VPWR sky130_fd_sc_hd__fill_1
XFILLER_24_27 VGND VGND VPWR VPWR sky130_fd_sc_hd__fill_1
XTAP_TAPCELL_ROW_56_610 VGND VPWR sky130_fd_sc_hd__tapvpwrvgnd_1
XFILLER_45_169 VPWR VGND VPWR VGND sky130_ef_sc_hd__decap_12
XFILLER_60_139 VGND VGND VPWR VPWR sky130_fd_sc_hd__fill_1
XFILLER_41_353 VPWR VGND VPWR VGND sky130_ef_sc_hd__decap_12
XTAP_TAPCELL_ROW_28_389 VGND VPWR sky130_fd_sc_hd__tapvpwrvgnd_1
XFILLER_26_361 VGND VGND VPWR VPWR sky130_fd_sc_hd__decap_3
XFILLER_64_401 VPWR VGND VPWR VGND sky130_ef_sc_hd__decap_12
X_1260_ net51 net161 _0308_ VGND VGND VPWR VPWR _0136_ sky130_fd_sc_hd__a21bo_1
X_1191_ net49 net171 _0273_ VGND VGND VPWR VPWR _0102_ sky130_fd_sc_hd__a21bo_1
Xinput8 host_input_addr[16] VGND VGND VPWR VPWR net8 sky130_fd_sc_hd__buf_1
XFILLER_64_445 VGND VGND VPWR VPWR sky130_fd_sc_hd__decap_8
XTAP_TAPCELL_ROW_62_657 VGND VPWR sky130_fd_sc_hd__tapvpwrvgnd_1
XFILLER_36_103 VGND VGND VPWR VPWR sky130_fd_sc_hd__fill_2
XFILLER_24_309 VPWR VGND VPWR VGND sky130_ef_sc_hd__decap_12
XTAP_TAPCELL_ROW_19_312 VGND VPWR sky130_fd_sc_hd__tapvpwrvgnd_1
X_0975_ net209 _0712_ _0715_ VGND VGND VPWR VPWR net88 sky130_fd_sc_hd__and3_1
X_1527_ net299 net107 _0471_ VGND VGND VPWR VPWR _0240_ sky130_fd_sc_hd__a21o_1
XFILLER_10_18 VGND VGND VPWR VPWR sky130_fd_sc_hd__decap_8
XFILLER_10_29 VPWR VGND VPWR VGND sky130_ef_sc_hd__decap_12
XFILLER_74_209 VPWR VGND VPWR VGND sky130_ef_sc_hd__decap_12
XFILLER_55_401 VGND VGND VPWR VPWR sky130_fd_sc_hd__fill_2
X_1389_ scratch\[0\]\[13\] scratch\[0\]\[14\] _0384_ VGND VGND VPWR VPWR _0389_ sky130_fd_sc_hd__and3_1
X_1458_ _0585_ _0441_ net149 VGND VGND VPWR VPWR _0442_ sky130_fd_sc_hd__o21ai_1
XFILLER_51_14 VGND VGND VPWR VPWR sky130_fd_sc_hd__decap_3
XFILLER_15_309 VGND VGND VPWR VPWR sky130_fd_sc_hd__decap_8
XFILLER_46_401 VPWR VGND VPWR VGND sky130_ef_sc_hd__decap_12
XFILLER_18_169 VGND VGND VPWR VPWR sky130_fd_sc_hd__decap_4
XFILLER_25_70 VGND VGND VPWR VPWR sky130_fd_sc_hd__fill_1
XFILLER_51_6 VGND VGND VPWR VPWR sky130_fd_sc_hd__decap_8
X_1174_ net11 net202 net183 net32 VGND VGND VPWR VPWR _0810_ sky130_fd_sc_hd__a22o_1
XFILLER_49_272 VGND VGND VPWR VPWR sky130_fd_sc_hd__decap_8
XFILLER_2_85 VPWR VGND VPWR VGND sky130_ef_sc_hd__decap_12
XFILLER_2_41 VPWR VGND VPWR VGND sky130_ef_sc_hd__decap_12
X_1243_ net46 net170 _0299_ VGND VGND VPWR VPWR _0128_ sky130_fd_sc_hd__a21bo_1
X_1312_ net211 net69 net70 VGND VGND VPWR VPWR _0335_ sky130_fd_sc_hd__a21o_1
XTAP_TAPCELL_ROW_75_771 VGND VPWR sky130_fd_sc_hd__tapvpwrvgnd_1
XTAP_TAPCELL_ROW_75_760 VGND VPWR sky130_fd_sc_hd__tapvpwrvgnd_1
XFILLER_24_139 VGND VGND VPWR VPWR sky130_fd_sc_hd__fill_1
X_0958_ scratch\[6\]\[19\] scratch\[7\]\[19\] net272 VGND VGND VPWR VPWR _0701_ sky130_fd_sc_hd__mux2_1
X_0889_ scratch\[0\]\[8\] net223 _0642_ net255 net248 VGND VGND VPWR VPWR _0643_ sky130_fd_sc_hd__a221o_1
XFILLER_21_17 VPWR VGND VPWR VGND sky130_ef_sc_hd__decap_12
XFILLER_70_245 VGND VGND VPWR VPWR sky130_fd_sc_hd__decap_6
XFILLER_43_404 VGND VGND VPWR VPWR sky130_fd_sc_hd__fill_1
XFILLER_70_289 VPWR VGND VPWR VGND sky130_ef_sc_hd__decap_12
XFILLER_7_305 VPWR VGND VPWR VGND sky130_ef_sc_hd__decap_12
XFILLER_7_349 VPWR VGND VPWR VGND sky130_ef_sc_hd__decap_12
XFILLER_38_209 VGND VGND VPWR VPWR sky130_fd_sc_hd__fill_1
XFILLER_19_412 VPWR VGND VPWR VGND sky130_ef_sc_hd__decap_12
XFILLER_19_445 VGND VGND VPWR VPWR sky130_fd_sc_hd__decap_3
XTAP_TAPCELL_ROW_72_741 VGND VPWR sky130_fd_sc_hd__tapvpwrvgnd_1
XFILLER_46_253 VGND VGND VPWR VPWR sky130_fd_sc_hd__fill_2
XFILLER_36_91 VGND VGND VPWR VPWR sky130_fd_sc_hd__decap_4
XFILLER_14_172 VGND VGND VPWR VPWR sky130_fd_sc_hd__fill_1
Xinput11 host_input_addr[19] VGND VGND VPWR VPWR net11 sky130_fd_sc_hd__buf_1
X_1792_ clknet_leaf_4_clock _0135_ VGND VGND VPWR VPWR scratch\[7\]\[6\] sky130_fd_sc_hd__dfxtp_1
Xinput33 host_input_data[1] VGND VGND VPWR VPWR net33 sky130_fd_sc_hd__buf_2
Xinput22 host_input_data[0] VGND VGND VPWR VPWR net22 sky130_fd_sc_hd__buf_2
Xinput55 host_output_addr[0] VGND VGND VPWR VPWR net55 sky130_fd_sc_hd__clkbuf_1
Xinput66 reset VGND VGND VPWR VPWR net66 sky130_fd_sc_hd__buf_1
Xinput44 host_input_data[2] VGND VGND VPWR VPWR net44 sky130_fd_sc_hd__buf_2
X_1861_ clknet_leaf_25_clock _0203_ VGND VGND VPWR VPWR scratch\[3\]\[0\] sky130_fd_sc_hd__dfxtp_1
X_1157_ net389 net122 _0801_ VGND VGND VPWR VPWR _0086_ sky130_fd_sc_hd__a21o_1
X_1226_ net246 net176 scratch\[6\]\[23\] VGND VGND VPWR VPWR _0291_ sky130_fd_sc_hd__or3b_1
XFILLER_52_289 VPWR VGND VPWR VGND sky130_ef_sc_hd__decap_12
XTAP_TAPCELL_ROW_35_443 VGND VPWR sky130_fd_sc_hd__tapvpwrvgnd_1
X_1088_ _0578_ _0780_ _0781_ _0769_ VGND VGND VPWR VPWR _0786_ sky130_fd_sc_hd__or4b_1
XFILLER_20_197 VPWR VGND VPWR VGND sky130_ef_sc_hd__decap_12
XFILLER_75_337 VPWR VGND VPWR VGND sky130_ef_sc_hd__decap_12
XFILLER_75_304 VGND VGND VPWR VPWR sky130_fd_sc_hd__decap_4
XFILLER_57_46 VGND VGND VPWR VPWR sky130_fd_sc_hd__fill_1
XFILLER_28_253 VPWR VGND VPWR VGND sky130_ef_sc_hd__decap_12
XFILLER_7_113 VPWR VGND VPWR VGND sky130_ef_sc_hd__decap_12
XFILLER_22_71 VGND VGND VPWR VPWR sky130_fd_sc_hd__fill_1
XFILLER_3_385 VGND VGND VPWR VPWR sky130_fd_sc_hd__decap_6
XFILLER_66_326 VPWR VGND VPWR VGND sky130_ef_sc_hd__decap_12
XTAP_TAPCELL_ROW_49_557 VGND VPWR sky130_fd_sc_hd__tapvpwrvgnd_1
X_1011_ scratch\[1\]\[28\] net217 _0744_ net259 net250 VGND VGND VPWR VPWR _0745_
+ sky130_fd_sc_hd__a221o_1
XFILLER_19_297 VPWR VGND VPWR VGND sky130_ef_sc_hd__decap_12
X_1913_ clknet_leaf_12_clock _0255_ VGND VGND VPWR VPWR scratch\[1\]\[20\] sky130_fd_sc_hd__dfxtp_1
XFILLER_22_429 VGND VGND VPWR VPWR sky130_fd_sc_hd__fill_1
XFILLER_22_418 VGND VGND VPWR VPWR sky130_fd_sc_hd__fill_2
X_1775_ clknet_leaf_13_clock _0118_ VGND VGND VPWR VPWR scratch\[6\]\[21\] sky130_fd_sc_hd__dfxtp_1
X_1844_ clknet_leaf_16_clock _0186_ VGND VGND VPWR VPWR scratch\[0\]\[15\] sky130_fd_sc_hd__dfxtp_1
XFILLER_69_186 VGND VGND VPWR VPWR sky130_fd_sc_hd__decap_8
XFILLER_72_307 VGND VGND VPWR VPWR sky130_fd_sc_hd__fill_1
X_1209_ net27 net172 _0282_ VGND VGND VPWR VPWR _0111_ sky130_fd_sc_hd__a21bo_1
XFILLER_0_333 VGND VGND VPWR VPWR sky130_fd_sc_hd__decap_3
XFILLER_75_178 VGND VGND VPWR VPWR sky130_fd_sc_hd__decap_3
XFILLER_75_145 VGND VGND VPWR VPWR sky130_fd_sc_hd__fill_1
XFILLER_0_377 VPWR VGND VPWR VGND sky130_ef_sc_hd__decap_12
XFILLER_71_373 VPWR VGND VPWR VGND sky130_ef_sc_hd__decap_12
XTAP_TAPCELL_ROW_54_593 VGND VPWR sky130_fd_sc_hd__tapvpwrvgnd_1
XFILLER_33_70 VGND VGND VPWR VPWR sky130_fd_sc_hd__fill_1
XFILLER_16_245 VGND VGND VPWR VPWR sky130_fd_sc_hd__decap_6
X_1560_ net201 _0496_ _0497_ VGND VGND VPWR VPWR _0498_ sky130_fd_sc_hd__and3_1
XFILLER_8_433 VPWR VGND VPWR VGND sky130_ef_sc_hd__decap_12
XFILLER_39_337 VGND VGND VPWR VPWR sky130_fd_sc_hd__fill_2
X_1491_ net41 net144 net115 net409 VGND VGND VPWR VPWR _0230_ sky130_fd_sc_hd__a22o_1
XFILLER_3_193 VPWR VGND VPWR VGND sky130_ef_sc_hd__decap_12
X_1827_ clknet_leaf_0_clock _0169_ VGND VGND VPWR VPWR cycle_count\[3\] sky130_fd_sc_hd__dfxtp_1
XFILLER_13_18 VPWR VGND VPWR VGND sky130_ef_sc_hd__decap_12
X_1758_ clknet_leaf_2_clock _0101_ VGND VGND VPWR VPWR scratch\[6\]\[4\] sky130_fd_sc_hd__dfxtp_1
X_1689_ clknet_leaf_25_clock _0032_ VGND VGND VPWR VPWR scratch\[4\]\[31\] sky130_fd_sc_hd__dfxtp_1
XFILLER_57_156 VGND VGND VPWR VPWR sky130_fd_sc_hd__fill_1
XFILLER_38_26 VGND VGND VPWR VPWR sky130_fd_sc_hd__fill_2
XFILLER_53_373 VGND VGND VPWR VPWR sky130_fd_sc_hd__decap_4
XTAP_TAPCELL_ROW_43_508 VGND VPWR sky130_fd_sc_hd__tapvpwrvgnd_1
XTAP_TAPCELL_ROW_0_163 VGND VPWR sky130_fd_sc_hd__tapvpwrvgnd_1
XTAP_TAPCELL_ROW_0_152 VGND VPWR sky130_fd_sc_hd__tapvpwrvgnd_1
XTAP_TAPCELL_ROW_51_574 VGND VPWR sky130_fd_sc_hd__tapvpwrvgnd_1
XFILLER_5_447 VGND VGND VPWR VPWR sky130_fd_sc_hd__fill_1
XFILLER_21_281 VGND VGND VPWR VPWR sky130_fd_sc_hd__decap_4
XFILLER_21_292 VGND VGND VPWR VPWR sky130_fd_sc_hd__decap_6
XFILLER_0_141 VGND VGND VPWR VPWR sky130_fd_sc_hd__decap_4
XTAP_TAPCELL_ROW_8_230 VGND VPWR sky130_fd_sc_hd__tapvpwrvgnd_1
XFILLER_63_104 VGND VGND VPWR VPWR sky130_fd_sc_hd__decap_8
XFILLER_36_307 VGND VGND VPWR VPWR sky130_fd_sc_hd__fill_1
XFILLER_71_181 VPWR VGND VPWR VGND sky130_ef_sc_hd__decap_12
XTAP_TAPCELL_ROW_14_276 VGND VPWR sky130_fd_sc_hd__tapvpwrvgnd_1
X_0991_ scratch\[4\]\[24\] net226 net217 scratch\[5\]\[24\] net234 VGND VGND VPWR
+ VPWR _0729_ sky130_fd_sc_hd__a221o_1
X_1543_ scratch\[3\]\[9\] scratch\[2\]\[9\] VGND VGND VPWR VPWR _0484_ sky130_fd_sc_hd__nand2_1
X_1474_ net23 net143 net113 net432 VGND VGND VPWR VPWR _0213_ sky130_fd_sc_hd__a22o_1
X_1612_ net302 net109 _0539_ VGND VGND VPWR VPWR _0257_ sky130_fd_sc_hd__a21o_1
XFILLER_5_30 VPWR VGND VPWR VGND sky130_ef_sc_hd__decap_12
XFILLER_8_285 VPWR VGND VPWR VGND sky130_ef_sc_hd__decap_12
Xfanout209 net210 VGND VGND VPWR VPWR net209 sky130_fd_sc_hd__clkbuf_4
XFILLER_54_137 VGND VGND VPWR VPWR sky130_fd_sc_hd__decap_3
XFILLER_50_365 VGND VGND VPWR VPWR sky130_fd_sc_hd__fill_1
XFILLER_35_373 VGND VGND VPWR VPWR sky130_fd_sc_hd__decap_3
XFILLER_40_27 VGND VGND VPWR VPWR sky130_fd_sc_hd__fill_1
XTAP_TAPCELL_ROW_5_200 VGND VPWR sky130_fd_sc_hd__tapvpwrvgnd_1
XFILLER_65_57 VPWR VGND VPWR VGND sky130_ef_sc_hd__decap_12
XTAP_TAPCELL_ROW_56_611 VGND VPWR sky130_fd_sc_hd__tapvpwrvgnd_1
XFILLER_26_373 VPWR VGND VPWR VGND sky130_ef_sc_hd__decap_12
XFILLER_53_181 VGND VGND VPWR VPWR sky130_fd_sc_hd__decap_8
XFILLER_41_365 VGND VGND VPWR VPWR sky130_fd_sc_hd__decap_4
XFILLER_14_61 VGND VGND VPWR VPWR sky130_fd_sc_hd__decap_3
Xinput9 host_input_addr[17] VGND VGND VPWR VPWR net9 sky130_fd_sc_hd__buf_1
XFILLER_68_207 VGND VGND VPWR VPWR sky130_fd_sc_hd__fill_2
XFILLER_64_413 VGND VGND VPWR VPWR sky130_fd_sc_hd__decap_6
X_1190_ net241 net171 scratch\[6\]\[5\] VGND VGND VPWR VPWR _0273_ sky130_fd_sc_hd__or3b_1
XFILLER_39_91 VGND VGND VPWR VPWR sky130_fd_sc_hd__decap_6
XTAP_TAPCELL_ROW_19_313 VGND VPWR sky130_fd_sc_hd__tapvpwrvgnd_1
XTAP_TAPCELL_ROW_62_658 VGND VPWR sky130_fd_sc_hd__tapvpwrvgnd_1
XFILLER_51_107 VGND VGND VPWR VPWR sky130_fd_sc_hd__decap_4
XFILLER_44_192 VGND VGND VPWR VPWR sky130_fd_sc_hd__decap_4
XFILLER_32_365 VPWR VGND VPWR VGND sky130_ef_sc_hd__decap_12
X_0974_ net262 _0713_ _0714_ VGND VGND VPWR VPWR _0715_ sky130_fd_sc_hd__a21o_1
X_1526_ net49 _0470_ net138 VGND VGND VPWR VPWR _0471_ sky130_fd_sc_hd__mux2_1
X_1457_ scratch\[0\]\[28\] scratch\[0\]\[29\] scratch\[0\]\[30\] _0433_ VGND VGND
+ VPWR VPWR _0441_ sky130_fd_sc_hd__and4_1
X_1388_ net26 net154 net117 _0388_ VGND VGND VPWR VPWR _0184_ sky130_fd_sc_hd__a22o_1
XFILLER_23_354 VGND VGND VPWR VPWR sky130_fd_sc_hd__fill_1
XFILLER_58_251 VGND VGND VPWR VPWR sky130_fd_sc_hd__fill_1
XFILLER_46_413 VGND VGND VPWR VPWR sky130_fd_sc_hd__decap_6
Xclkbuf_leaf_0_clock clknet_2_0__leaf_clock VGND VGND VPWR VPWR clknet_leaf_0_clock
+ sky130_fd_sc_hd__clkbuf_8
XFILLER_61_449 VGND VGND VPWR VPWR sky130_fd_sc_hd__decap_4
XFILLER_61_405 VPWR VGND VPWR VGND sky130_ef_sc_hd__decap_12
XFILLER_46_435 VPWR VGND VPWR VGND sky130_ef_sc_hd__decap_12
XFILLER_14_365 VPWR VGND VPWR VGND sky130_ef_sc_hd__decap_12
X_1311_ net211 net443 _0334_ VGND VGND VPWR VPWR _0161_ sky130_fd_sc_hd__o21a_1
XTAP_TAPCELL_ROW_75_772 VGND VPWR sky130_fd_sc_hd__tapvpwrvgnd_1
XTAP_TAPCELL_ROW_75_761 VGND VPWR sky130_fd_sc_hd__tapvpwrvgnd_1
XFILLER_64_221 VGND VGND VPWR VPWR sky130_fd_sc_hd__decap_3
X_1173_ net377 net124 _0809_ VGND VGND VPWR VPWR _0094_ sky130_fd_sc_hd__a21o_1
XFILLER_24_107 VGND VGND VPWR VPWR sky130_fd_sc_hd__fill_1
XFILLER_2_97 VPWR VGND VPWR VGND sky130_ef_sc_hd__decap_12
XFILLER_2_53 VPWR VGND VPWR VGND sky130_ef_sc_hd__decap_12
XPHY_EDGE_ROW_10_Right_10 VGND VGND VPWR VPWR sky130_fd_sc_hd__decap_3
X_1242_ net237 net170 scratch\[6\]\[31\] VGND VGND VPWR VPWR _0299_ sky130_fd_sc_hd__or3b_1
X_0957_ scratch\[1\]\[19\] net220 _0699_ VGND VGND VPWR VPWR _0700_ sky130_fd_sc_hd__a21o_1
X_0888_ scratch\[2\]\[8\] scratch\[3\]\[8\] net265 VGND VGND VPWR VPWR _0642_ sky130_fd_sc_hd__mux2_1
XFILLER_9_391 VGND VGND VPWR VPWR sky130_fd_sc_hd__fill_1
XFILLER_21_29 VGND VGND VPWR VPWR sky130_fd_sc_hd__decap_8
X_1509_ scratch\[3\]\[2\] scratch\[2\]\[2\] VGND VGND VPWR VPWR _0457_ sky130_fd_sc_hd__or2_1
XFILLER_62_58 VGND VGND VPWR VPWR sky130_fd_sc_hd__fill_2
XFILLER_7_317 VPWR VGND VPWR VGND sky130_ef_sc_hd__decap_12
XFILLER_11_335 VGND VGND VPWR VPWR sky130_fd_sc_hd__fill_1
XTAP_TAPCELL_ROW_21_330 VGND VPWR sky130_fd_sc_hd__tapvpwrvgnd_1
XFILLER_11_73 VGND VGND VPWR VPWR sky130_fd_sc_hd__decap_6
XFILLER_46_243 VGND VGND VPWR VPWR sky130_fd_sc_hd__decap_8
XFILLER_46_221 VPWR VGND VPWR VGND sky130_ef_sc_hd__decap_12
XFILLER_34_416 VGND VGND VPWR VPWR sky130_fd_sc_hd__decap_4
XFILLER_19_424 VGND VGND VPWR VPWR sky130_fd_sc_hd__fill_1
XTAP_TAPCELL_ROW_72_742 VGND VPWR sky130_fd_sc_hd__tapvpwrvgnd_1
XFILLER_61_279 VGND VGND VPWR VPWR sky130_fd_sc_hd__fill_1
XFILLER_61_246 VPWR VGND VPWR VGND sky130_ef_sc_hd__decap_12
XFILLER_34_427 VGND VGND VPWR VPWR sky130_fd_sc_hd__decap_6
X_1860_ clknet_leaf_24_clock _0202_ VGND VGND VPWR VPWR scratch\[0\]\[31\] sky130_fd_sc_hd__dfxtp_1
XFILLER_14_184 VPWR VGND VPWR VGND sky130_ef_sc_hd__decap_12
Xinput23 host_input_data[10] VGND VGND VPWR VPWR net23 sky130_fd_sc_hd__buf_2
Xinput34 host_input_data[20] VGND VGND VPWR VPWR net34 sky130_fd_sc_hd__buf_2
X_1791_ clknet_leaf_4_clock _0134_ VGND VGND VPWR VPWR scratch\[7\]\[5\] sky130_fd_sc_hd__dfxtp_1
Xinput12 host_input_addr[1] VGND VGND VPWR VPWR net12 sky130_fd_sc_hd__buf_1
Xinput67 start VGND VGND VPWR VPWR net67 sky130_fd_sc_hd__clkbuf_1
Xinput45 host_input_data[30] VGND VGND VPWR VPWR net45 sky130_fd_sc_hd__buf_2
Xinput56 host_output_addr[10] VGND VGND VPWR VPWR net56 sky130_fd_sc_hd__clkbuf_1
XFILLER_69_335 VGND VGND VPWR VPWR sky130_fd_sc_hd__fill_1
X_1156_ net2 net197 net180 net23 VGND VGND VPWR VPWR _0801_ sky130_fd_sc_hd__a22o_1
X_1225_ net36 net176 _0290_ VGND VGND VPWR VPWR _0119_ sky130_fd_sc_hd__a21bo_1
XFILLER_37_243 VGND VGND VPWR VPWR sky130_fd_sc_hd__decap_3
XTAP_TAPCELL_ROW_35_444 VGND VPWR sky130_fd_sc_hd__tapvpwrvgnd_1
X_1087_ _0784_ net276 net274 VGND VGND VPWR VPWR _0785_ sky130_fd_sc_hd__nor3b_1
XFILLER_25_449 VGND VGND VPWR VPWR sky130_fd_sc_hd__decap_4
XFILLER_25_405 VPWR VGND VPWR VGND sky130_ef_sc_hd__decap_12
XFILLER_4_309 VPWR VGND VPWR VGND sky130_ef_sc_hd__decap_12
XFILLER_75_349 VGND VGND VPWR VPWR sky130_fd_sc_hd__decap_6
XFILLER_28_265 VGND VGND VPWR VPWR sky130_fd_sc_hd__decap_8
XFILLER_73_57 VPWR VGND VPWR VGND sky130_ef_sc_hd__decap_12
XFILLER_7_125 VPWR VGND VPWR VGND sky130_ef_sc_hd__decap_12
XFILLER_7_169 VPWR VGND VPWR VGND sky130_ef_sc_hd__decap_12
XFILLER_66_338 VGND VGND VPWR VPWR sky130_fd_sc_hd__decap_8
XTAP_TAPCELL_ROW_49_558 VGND VPWR sky130_fd_sc_hd__tapvpwrvgnd_1
XFILLER_47_80 VPWR VGND VPWR VGND sky130_ef_sc_hd__decap_12
X_1010_ scratch\[2\]\[28\] scratch\[3\]\[28\] net270 VGND VGND VPWR VPWR _0744_ sky130_fd_sc_hd__mux2_1
X_1912_ clknet_leaf_12_clock _0254_ VGND VGND VPWR VPWR scratch\[1\]\[19\] sky130_fd_sc_hd__dfxtp_1
X_1843_ clknet_leaf_8_clock _0185_ VGND VGND VPWR VPWR scratch\[0\]\[14\] sky130_fd_sc_hd__dfxtp_1
XTAP_TAPCELL_ROW_40_480 VGND VPWR sky130_fd_sc_hd__tapvpwrvgnd_1
XFILLER_34_279 VPWR VGND VPWR VGND sky130_ef_sc_hd__decap_12
XFILLER_8_41 VPWR VGND VPWR VGND sky130_ef_sc_hd__decap_12
XFILLER_8_85 VGND VGND VPWR VPWR sky130_fd_sc_hd__decap_6
X_1774_ clknet_leaf_13_clock _0117_ VGND VGND VPWR VPWR scratch\[6\]\[20\] sky130_fd_sc_hd__dfxtp_1
X_1208_ net240 net172 scratch\[6\]\[14\] VGND VGND VPWR VPWR _0282_ sky130_fd_sc_hd__or3b_1
XFILLER_65_393 VPWR VGND VPWR VGND sky130_ef_sc_hd__decap_12
XFILLER_65_371 VPWR VGND VPWR VGND sky130_ef_sc_hd__decap_12
XFILLER_43_16 VGND VGND VPWR VPWR sky130_fd_sc_hd__fill_1
XFILLER_40_238 VGND VGND VPWR VPWR sky130_fd_sc_hd__fill_2
X_1139_ net390 net121 _0792_ VGND VGND VPWR VPWR _0077_ sky130_fd_sc_hd__a21o_1
XFILLER_4_139 VGND VGND VPWR VPWR sky130_fd_sc_hd__fill_1
XFILLER_0_389 VGND VGND VPWR VPWR sky130_fd_sc_hd__decap_3
XFILLER_75_113 VPWR VGND VPWR VGND sky130_ef_sc_hd__decap_12
XTAP_TAPCELL_ROW_46_528 VGND VPWR sky130_fd_sc_hd__tapvpwrvgnd_1
XFILLER_71_385 VGND VGND VPWR VPWR sky130_fd_sc_hd__decap_6
XTAP_TAPCELL_ROW_54_594 VGND VPWR sky130_fd_sc_hd__tapvpwrvgnd_1
XFILLER_24_290 VPWR VGND VPWR VGND sky130_ef_sc_hd__decap_12
XFILLER_8_401 VPWR VGND VPWR VGND sky130_ef_sc_hd__decap_12
XFILLER_8_445 VGND VGND VPWR VPWR sky130_fd_sc_hd__decap_8
XPHY_EDGE_ROW_9_Left_85 VGND VGND VPWR VPWR sky130_fd_sc_hd__decap_3
XFILLER_12_441 VGND VGND VPWR VPWR sky130_fd_sc_hd__decap_8
X_1490_ net40 net145 net115 net420 VGND VGND VPWR VPWR _0229_ sky130_fd_sc_hd__a22o_1
XFILLER_3_161 VGND VGND VPWR VPWR sky130_fd_sc_hd__decap_6
XFILLER_66_157 VGND VGND VPWR VPWR sky130_fd_sc_hd__decap_8
XFILLER_39_305 VGND VGND VPWR VPWR sky130_fd_sc_hd__decap_6
Xhold1 scratch\[1\]\[27\] VGND VGND VPWR VPWR net277 sky130_fd_sc_hd__dlygate4sd3_1
XFILLER_62_363 VGND VGND VPWR VPWR sky130_fd_sc_hd__fill_1
XFILLER_62_341 VGND VGND VPWR VPWR sky130_fd_sc_hd__fill_2
XFILLER_47_393 VPWR VGND VPWR VGND sky130_ef_sc_hd__decap_12
XPHY_EDGE_ROW_8_Right_8 VGND VGND VPWR VPWR sky130_fd_sc_hd__decap_3
XTAP_TAPCELL_ROW_17_296 VGND VPWR sky130_fd_sc_hd__tapvpwrvgnd_1
X_1826_ clknet_leaf_0_clock _0168_ VGND VGND VPWR VPWR cycle_count\[2\] sky130_fd_sc_hd__dfxtp_1
XPHY_EDGE_ROW_39_Right_39 VGND VGND VPWR VPWR sky130_fd_sc_hd__decap_3
X_1757_ clknet_leaf_27_clock _0100_ VGND VGND VPWR VPWR scratch\[6\]\[3\] sky130_fd_sc_hd__dfxtp_1
X_1688_ clknet_leaf_26_clock _0031_ VGND VGND VPWR VPWR scratch\[4\]\[30\] sky130_fd_sc_hd__dfxtp_1
XFILLER_57_113 VPWR VGND VPWR VGND sky130_ef_sc_hd__decap_12
XFILLER_54_15 VPWR VGND VPWR VGND sky130_ef_sc_hd__decap_12
XTAP_TAPCELL_ROW_0_153 VGND VPWR sky130_fd_sc_hd__tapvpwrvgnd_1
XFILLER_53_385 VGND VGND VPWR VPWR sky130_fd_sc_hd__decap_6
XTAP_TAPCELL_ROW_51_575 VGND VPWR sky130_fd_sc_hd__tapvpwrvgnd_1
XPHY_EDGE_ROW_48_Right_48 VGND VGND VPWR VPWR sky130_fd_sc_hd__decap_3
XTAP_TAPCELL_ROW_43_509 VGND VPWR sky130_fd_sc_hd__tapvpwrvgnd_1
XTAP_TAPCELL_ROW_0_164 VGND VPWR sky130_fd_sc_hd__tapvpwrvgnd_1
XFILLER_13_216 VGND VGND VPWR VPWR sky130_fd_sc_hd__fill_2
XFILLER_13_249 VGND VGND VPWR VPWR sky130_fd_sc_hd__decap_3
XFILLER_21_260 VPWR VGND VPWR VGND sky130_ef_sc_hd__decap_12
XPHY_EDGE_ROW_57_Right_57 VGND VGND VPWR VPWR sky130_fd_sc_hd__decap_3
XFILLER_0_131 VGND VGND VPWR VPWR sky130_fd_sc_hd__fill_1
XFILLER_0_186 VGND VGND VPWR VPWR sky130_fd_sc_hd__fill_2
XFILLER_0_197 VPWR VGND VPWR VGND sky130_ef_sc_hd__decap_12
XTAP_TAPCELL_ROW_8_231 VGND VPWR sky130_fd_sc_hd__tapvpwrvgnd_1
XFILLER_71_193 VPWR VGND VPWR VGND sky130_ef_sc_hd__decap_12
XPHY_EDGE_ROW_66_Right_66 VGND VGND VPWR VPWR sky130_fd_sc_hd__decap_3
XFILLER_29_393 VGND VGND VPWR VPWR sky130_fd_sc_hd__decap_4
XFILLER_29_360 VPWR VGND VPWR VGND sky130_ef_sc_hd__decap_12
XFILLER_28_82 VGND VGND VPWR VPWR sky130_fd_sc_hd__fill_2
X_1611_ net36 _0538_ net139 VGND VGND VPWR VPWR _0539_ sky130_fd_sc_hd__mux2_1
XFILLER_8_253 VPWR VGND VPWR VGND sky130_ef_sc_hd__decap_12
XFILLER_8_297 VGND VGND VPWR VPWR sky130_fd_sc_hd__decap_8
XTAP_TAPCELL_ROW_14_277 VGND VPWR sky130_fd_sc_hd__tapvpwrvgnd_1
X_0990_ net258 _0727_ VGND VGND VPWR VPWR _0728_ sky130_fd_sc_hd__and2_1
XPHY_EDGE_ROW_75_Right_75 VGND VGND VPWR VPWR sky130_fd_sc_hd__decap_3
X_1473_ net53 net143 net113 net430 VGND VGND VPWR VPWR _0212_ sky130_fd_sc_hd__a22o_1
X_1542_ net298 net107 _0483_ VGND VGND VPWR VPWR _0243_ sky130_fd_sc_hd__a21o_1
XFILLER_5_42 VPWR VGND VPWR VGND sky130_ef_sc_hd__decap_12
XFILLER_54_116 VGND VGND VPWR VPWR sky130_fd_sc_hd__decap_4
XFILLER_27_308 VGND VGND VPWR VPWR sky130_fd_sc_hd__fill_2
XPHY_EDGE_ROW_59_Left_135 VGND VGND VPWR VPWR sky130_fd_sc_hd__decap_3
XFILLER_50_355 VGND VGND VPWR VPWR sky130_fd_sc_hd__fill_1
XFILLER_24_29 VGND VGND VPWR VPWR sky130_fd_sc_hd__fill_1
XPHY_EDGE_ROW_68_Left_144 VGND VGND VPWR VPWR sky130_fd_sc_hd__decap_3
X_1809_ clknet_leaf_14_clock _0152_ VGND VGND VPWR VPWR scratch\[7\]\[23\] sky130_fd_sc_hd__dfxtp_1
XFILLER_49_15 VPWR VGND VPWR VGND sky130_ef_sc_hd__decap_12
XTAP_TAPCELL_ROW_5_201 VGND VPWR sky130_fd_sc_hd__tapvpwrvgnd_1
XFILLER_73_447 VGND VGND VPWR VPWR sky130_fd_sc_hd__fill_1
XFILLER_65_69 VPWR VGND VPWR VGND sky130_ef_sc_hd__decap_12
XTAP_TAPCELL_ROW_56_612 VGND VPWR sky130_fd_sc_hd__tapvpwrvgnd_1
XFILLER_41_311 VGND VGND VPWR VPWR sky130_fd_sc_hd__decap_8
XFILLER_26_385 VPWR VGND VPWR VGND sky130_ef_sc_hd__decap_12
XFILLER_41_399 VGND VGND VPWR VPWR sky130_fd_sc_hd__fill_1
XFILLER_30_50 VGND VGND VPWR VPWR sky130_fd_sc_hd__decap_8
XFILLER_5_223 VGND VGND VPWR VPWR sky130_fd_sc_hd__fill_1
XTAP_TAPCELL_ROW_19_314 VGND VPWR sky130_fd_sc_hd__tapvpwrvgnd_1
XTAP_TAPCELL_ROW_62_659 VGND VPWR sky130_fd_sc_hd__tapvpwrvgnd_1
XFILLER_44_171 VGND VGND VPWR VPWR sky130_fd_sc_hd__decap_4
XFILLER_32_377 VGND VGND VPWR VPWR sky130_fd_sc_hd__fill_1
XTAP_TAPCELL_ROW_27_380 VGND VPWR sky130_fd_sc_hd__tapvpwrvgnd_1
XFILLER_72_3 VPWR VGND VPWR VGND sky130_ef_sc_hd__decap_12
X_0973_ scratch\[4\]\[21\] net229 net219 scratch\[5\]\[21\] net233 VGND VGND VPWR
+ VPWR _0714_ sky130_fd_sc_hd__a221o_1
X_1525_ net196 _0468_ _0469_ VGND VGND VPWR VPWR _0470_ sky130_fd_sc_hd__and3_1
X_1387_ _0386_ _0387_ VGND VGND VPWR VPWR _0388_ sky130_fd_sc_hd__nor2_1
X_1456_ _0348_ _0438_ scratch\[0\]\[30\] VGND VGND VPWR VPWR _0440_ sky130_fd_sc_hd__o21bai_1
XFILLER_55_447 VGND VGND VPWR VPWR sky130_fd_sc_hd__fill_1
XFILLER_42_108 VPWR VGND VPWR VGND sky130_ef_sc_hd__decap_12
XFILLER_50_141 VGND VGND VPWR VPWR sky130_fd_sc_hd__decap_8
XFILLER_58_296 VGND VGND VPWR VPWR sky130_fd_sc_hd__fill_1
XFILLER_46_447 VGND VGND VPWR VPWR sky130_fd_sc_hd__fill_2
XFILLER_18_138 VGND VGND VPWR VPWR sky130_fd_sc_hd__fill_2
XFILLER_61_417 VPWR VGND VPWR VGND sky130_ef_sc_hd__decap_12
XFILLER_41_141 VGND VGND VPWR VPWR sky130_fd_sc_hd__decap_4
XFILLER_33_119 VGND VGND VPWR VPWR sky130_fd_sc_hd__decap_8
XFILLER_14_377 VPWR VGND VPWR VGND sky130_ef_sc_hd__decap_12
XFILLER_1_281 VPWR VGND VPWR VGND sky130_ef_sc_hd__decap_12
X_1241_ net45 net170 _0298_ VGND VGND VPWR VPWR _0127_ sky130_fd_sc_hd__a21bo_1
X_1310_ net211 net69 net205 VGND VGND VPWR VPWR _0334_ sky130_fd_sc_hd__a21boi_1
XPHY_EDGE_ROW_22_Left_98 VGND VGND VPWR VPWR sky130_fd_sc_hd__decap_3
XTAP_TAPCELL_ROW_75_773 VGND VPWR sky130_fd_sc_hd__tapvpwrvgnd_1
XTAP_TAPCELL_ROW_75_762 VGND VPWR sky130_fd_sc_hd__tapvpwrvgnd_1
XFILLER_64_277 VPWR VGND VPWR VGND sky130_ef_sc_hd__decap_12
XFILLER_49_296 VGND VGND VPWR VPWR sky130_fd_sc_hd__decap_6
XFILLER_49_263 VGND VGND VPWR VPWR sky130_fd_sc_hd__fill_1
XFILLER_37_425 VPWR VGND VPWR VGND sky130_ef_sc_hd__decap_12
X_1172_ net10 net199 net182 net31 VGND VGND VPWR VPWR _0809_ sky130_fd_sc_hd__a22o_1
XFILLER_2_65 VPWR VGND VPWR VGND sky130_ef_sc_hd__decap_12
X_0956_ scratch\[0\]\[19\] net228 _0698_ net260 net251 VGND VGND VPWR VPWR _0699_
+ sky130_fd_sc_hd__a221o_1
X_0887_ net207 _0638_ _0641_ VGND VGND VPWR VPWR net104 sky130_fd_sc_hd__and3_1
Xoutput100 net100 VGND VGND VPWR VPWR host_output_data[3] sky130_fd_sc_hd__clkbuf_4
XFILLER_55_233 VGND VGND VPWR VPWR sky130_fd_sc_hd__decap_3
XFILLER_46_27 VGND VGND VPWR VPWR sky130_fd_sc_hd__fill_1
X_1439_ scratch\[0\]\[24\] scratch\[0\]\[25\] net153 _0421_ scratch\[0\]\[26\] VGND
+ VGND VPWR VPWR _0427_ sky130_fd_sc_hd__a41o_1
X_1508_ scratch\[3\]\[2\] scratch\[2\]\[2\] VGND VGND VPWR VPWR _0456_ sky130_fd_sc_hd__nand2_1
XTAP_TAPCELL_ROW_38_464 VGND VPWR sky130_fd_sc_hd__tapvpwrvgnd_1
XFILLER_23_141 VGND VGND VPWR VPWR sky130_fd_sc_hd__decap_8
XFILLER_11_303 VPWR VGND VPWR VGND sky130_ef_sc_hd__decap_12
XFILLER_23_196 VGND VGND VPWR VPWR sky130_fd_sc_hd__decap_3
XFILLER_7_329 VGND VGND VPWR VPWR sky130_fd_sc_hd__decap_6
XFILLER_11_30 VGND VGND VPWR VPWR sky130_fd_sc_hd__decap_8
XTAP_TAPCELL_ROW_21_331 VGND VPWR sky130_fd_sc_hd__tapvpwrvgnd_1
XFILLER_2_3 VPWR VGND VPWR VGND sky130_ef_sc_hd__decap_12
XFILLER_61_225 VGND VGND VPWR VPWR sky130_fd_sc_hd__decap_6
XFILLER_46_233 VGND VGND VPWR VPWR sky130_fd_sc_hd__decap_4
XTAP_TAPCELL_ROW_72_743 VGND VPWR sky130_fd_sc_hd__tapvpwrvgnd_1
XFILLER_61_258 VGND VGND VPWR VPWR sky130_fd_sc_hd__decap_6
Xinput13 host_input_addr[20] VGND VGND VPWR VPWR net13 sky130_fd_sc_hd__buf_1
X_1790_ clknet_leaf_2_clock _0133_ VGND VGND VPWR VPWR scratch\[7\]\[4\] sky130_fd_sc_hd__dfxtp_1
XFILLER_14_141 VGND VGND VPWR VPWR sky130_fd_sc_hd__decap_4
Xinput24 host_input_data[11] VGND VGND VPWR VPWR net24 sky130_fd_sc_hd__buf_2
Xinput35 host_input_data[21] VGND VGND VPWR VPWR net35 sky130_fd_sc_hd__clkbuf_2
Xinput46 host_input_data[31] VGND VGND VPWR VPWR net46 sky130_fd_sc_hd__buf_2
Xinput57 host_output_addr[1] VGND VGND VPWR VPWR net57 sky130_fd_sc_hd__buf_1
X_1224_ net243 net176 scratch\[6\]\[22\] VGND VGND VPWR VPWR _0290_ sky130_fd_sc_hd__or3b_1
X_1155_ net394 net126 _0800_ VGND VGND VPWR VPWR _0085_ sky130_fd_sc_hd__a21o_1
XFILLER_37_288 VGND VGND VPWR VPWR sky130_fd_sc_hd__fill_2
XTAP_TAPCELL_ROW_35_445 VGND VPWR sky130_fd_sc_hd__tapvpwrvgnd_1
X_1086_ net1 _0769_ _0772_ _0776_ VGND VGND VPWR VPWR _0784_ sky130_fd_sc_hd__nand4_1
XFILLER_25_417 VGND VGND VPWR VPWR sky130_fd_sc_hd__decap_8
XFILLER_60_280 VPWR VGND VPWR VGND sky130_ef_sc_hd__decap_12
X_0939_ scratch\[6\]\[16\] scratch\[7\]\[16\] net271 VGND VGND VPWR VPWR _0685_ sky130_fd_sc_hd__mux2_1
XFILLER_32_29 VGND VGND VPWR VPWR sky130_fd_sc_hd__decap_4
XFILLER_32_18 VGND VGND VPWR VPWR sky130_fd_sc_hd__decap_8
XFILLER_20_155 VPWR VGND VPWR VGND sky130_ef_sc_hd__decap_12
XFILLER_20_188 VGND VGND VPWR VPWR sky130_fd_sc_hd__decap_8
XFILLER_57_15 VPWR VGND VPWR VGND sky130_ef_sc_hd__decap_12
XFILLER_75_317 VGND VGND VPWR VPWR sky130_fd_sc_hd__decap_4
XFILLER_73_69 VPWR VGND VPWR VGND sky130_ef_sc_hd__decap_12
XFILLER_43_247 VPWR VGND VPWR VGND sky130_ef_sc_hd__decap_12
XFILLER_11_111 VGND VGND VPWR VPWR sky130_fd_sc_hd__fill_1
XFILLER_11_133 VGND VGND VPWR VPWR sky130_fd_sc_hd__fill_1
XFILLER_7_137 VPWR VGND VPWR VGND sky130_ef_sc_hd__decap_12
XFILLER_11_166 VGND VGND VPWR VPWR sky130_fd_sc_hd__fill_2
Xfanout190 net193 VGND VGND VPWR VPWR net190 sky130_fd_sc_hd__buf_2
XFILLER_21_9 VGND VGND VPWR VPWR sky130_fd_sc_hd__fill_2
XTAP_TAPCELL_ROW_49_559 VGND VPWR sky130_fd_sc_hd__tapvpwrvgnd_1
XFILLER_47_92 VGND VGND VPWR VPWR sky130_fd_sc_hd__fill_2
X_1773_ clknet_leaf_12_clock _0116_ VGND VGND VPWR VPWR scratch\[6\]\[19\] sky130_fd_sc_hd__dfxtp_1
X_1842_ clknet_leaf_9_clock _0184_ VGND VGND VPWR VPWR scratch\[0\]\[13\] sky130_fd_sc_hd__dfxtp_1
XTAP_TAPCELL_ROW_40_481 VGND VPWR sky130_fd_sc_hd__tapvpwrvgnd_1
X_1911_ clknet_leaf_18_clock _0253_ VGND VGND VPWR VPWR scratch\[1\]\[18\] sky130_fd_sc_hd__dfxtp_1
XFILLER_8_53 VPWR VGND VPWR VGND sky130_ef_sc_hd__decap_12
XFILLER_69_111 VGND VGND VPWR VPWR sky130_fd_sc_hd__fill_1
XPHY_EDGE_ROW_31_Left_107 VGND VGND VPWR VPWR sky130_fd_sc_hd__decap_3
XFILLER_72_309 VPWR VGND VPWR VGND sky130_ef_sc_hd__decap_12
XFILLER_65_383 VGND VGND VPWR VPWR sky130_fd_sc_hd__decap_8
XPHY_EDGE_ROW_40_Left_116 VGND VGND VPWR VPWR sky130_fd_sc_hd__decap_3
X_1207_ net26 net169 _0281_ VGND VGND VPWR VPWR _0110_ sky130_fd_sc_hd__a21bo_1
XFILLER_40_217 VGND VGND VPWR VPWR sky130_fd_sc_hd__fill_1
X_1138_ net276 net194 net179 net33 VGND VGND VPWR VPWR _0792_ sky130_fd_sc_hd__a22o_1
XFILLER_25_225 VGND VGND VPWR VPWR sky130_fd_sc_hd__fill_2
X_1069_ net28 net192 net135 net340 VGND VGND VPWR VPWR _0016_ sky130_fd_sc_hd__a22o_1
XFILLER_48_317 VGND VGND VPWR VPWR sky130_fd_sc_hd__decap_3
XFILLER_48_306 VGND VGND VPWR VPWR sky130_fd_sc_hd__fill_2
XFILLER_75_158 VGND VGND VPWR VPWR sky130_fd_sc_hd__fill_2
XFILLER_56_361 VGND VGND VPWR VPWR sky130_fd_sc_hd__decap_3
XFILLER_56_350 VGND VGND VPWR VPWR sky130_fd_sc_hd__decap_3
XTAP_TAPCELL_ROW_46_529 VGND VPWR sky130_fd_sc_hd__tapvpwrvgnd_1
XTAP_TAPCELL_ROW_3_184 VGND VPWR sky130_fd_sc_hd__tapvpwrvgnd_1
XFILLER_16_214 VGND VGND VPWR VPWR sky130_fd_sc_hd__decap_3
XTAP_TAPCELL_ROW_54_595 VGND VPWR sky130_fd_sc_hd__tapvpwrvgnd_1
XFILLER_8_413 VGND VGND VPWR VPWR sky130_fd_sc_hd__decap_6
XFILLER_54_309 VGND VGND VPWR VPWR sky130_fd_sc_hd__decap_6
XFILLER_39_328 VGND VGND VPWR VPWR sky130_fd_sc_hd__decap_8
Xhold2 scratch\[1\]\[1\] VGND VGND VPWR VPWR net278 sky130_fd_sc_hd__dlygate4sd3_1
XTAP_TAPCELL_ROW_17_297 VGND VPWR sky130_fd_sc_hd__tapvpwrvgnd_1
X_1825_ clknet_leaf_0_clock _0167_ VGND VGND VPWR VPWR cycle_count\[1\] sky130_fd_sc_hd__dfxtp_1
X_1756_ clknet_leaf_28_clock _0099_ VGND VGND VPWR VPWR scratch\[6\]\[2\] sky130_fd_sc_hd__dfxtp_1
XFILLER_57_125 VGND VGND VPWR VPWR sky130_fd_sc_hd__fill_2
X_1687_ clknet_leaf_22_clock _0030_ VGND VGND VPWR VPWR scratch\[4\]\[29\] sky130_fd_sc_hd__dfxtp_1
XFILLER_72_139 VGND VGND VPWR VPWR sky130_fd_sc_hd__fill_1
XFILLER_57_169 VPWR VGND VPWR VGND sky130_ef_sc_hd__decap_12
XFILLER_57_136 VPWR VGND VPWR VGND sky130_ef_sc_hd__decap_12
XFILLER_54_49 VGND VGND VPWR VPWR sky130_fd_sc_hd__fill_2
XFILLER_54_27 VGND VGND VPWR VPWR sky130_fd_sc_hd__fill_1
XTAP_TAPCELL_ROW_0_165 VGND VPWR sky130_fd_sc_hd__tapvpwrvgnd_1
XTAP_TAPCELL_ROW_0_154 VGND VPWR sky130_fd_sc_hd__tapvpwrvgnd_1
XFILLER_70_15 VPWR VGND VPWR VGND sky130_ef_sc_hd__decap_12
XFILLER_53_397 VGND VGND VPWR VPWR sky130_fd_sc_hd__fill_1
XFILLER_21_272 VGND VGND VPWR VPWR sky130_fd_sc_hd__decap_8
XFILLER_5_449 VGND VGND VPWR VPWR sky130_fd_sc_hd__decap_4
XFILLER_5_405 VPWR VGND VPWR VGND sky130_ef_sc_hd__decap_12
XFILLER_63_128 VGND VGND VPWR VPWR sky130_fd_sc_hd__fill_1
XTAP_TAPCELL_ROW_59_632 VGND VPWR sky130_fd_sc_hd__tapvpwrvgnd_1
XFILLER_29_372 VGND VGND VPWR VPWR sky130_fd_sc_hd__fill_1
XFILLER_28_50 VPWR VGND VPWR VGND sky130_ef_sc_hd__decap_12
XFILLER_71_161 VGND VGND VPWR VPWR sky130_fd_sc_hd__decap_6
X_1610_ net199 _0536_ _0537_ VGND VGND VPWR VPWR _0538_ sky130_fd_sc_hd__and3_1
XFILLER_8_221 VPWR VGND VPWR VGND sky130_ef_sc_hd__decap_12
XTAP_TAPCELL_ROW_14_278 VGND VPWR sky130_fd_sc_hd__tapvpwrvgnd_1
X_1541_ net52 _0482_ net138 VGND VGND VPWR VPWR _0483_ sky130_fd_sc_hd__mux2_1
X_1472_ net52 net143 net113 net435 VGND VGND VPWR VPWR _0211_ sky130_fd_sc_hd__a22o_1
XFILLER_5_54 VGND VGND VPWR VPWR sky130_fd_sc_hd__fill_2
XFILLER_39_169 VGND VGND VPWR VPWR sky130_fd_sc_hd__fill_1
XFILLER_49_27 VPWR VGND VPWR VGND sky130_ef_sc_hd__decap_12
X_1808_ clknet_leaf_14_clock _0151_ VGND VGND VPWR VPWR scratch\[7\]\[22\] sky130_fd_sc_hd__dfxtp_1
XFILLER_40_29 VPWR VGND VPWR VGND sky130_ef_sc_hd__decap_12
X_1739_ clknet_leaf_4_clock _0082_ VGND VGND VPWR VPWR scratch\[2\]\[6\] sky130_fd_sc_hd__dfxtp_1
XFILLER_2_419 VGND VGND VPWR VPWR sky130_fd_sc_hd__fill_1
XFILLER_65_15 VPWR VGND VPWR VGND sky130_ef_sc_hd__decap_12
XFILLER_58_445 VGND VGND VPWR VPWR sky130_fd_sc_hd__decap_8
XFILLER_58_434 VGND VGND VPWR VPWR sky130_fd_sc_hd__decap_3
XTAP_TAPCELL_ROW_56_613 VGND VPWR sky130_fd_sc_hd__tapvpwrvgnd_1
XTAP_TAPCELL_ROW_5_202 VGND VPWR sky130_fd_sc_hd__tapvpwrvgnd_1
XFILLER_18_309 VGND VGND VPWR VPWR sky130_fd_sc_hd__decap_4
XFILLER_60_109 VGND VGND VPWR VPWR sky130_fd_sc_hd__decap_4
XFILLER_26_353 VGND VGND VPWR VPWR sky130_fd_sc_hd__decap_8
XTAP_TAPCELL_ROW_11_248 VGND VPWR sky130_fd_sc_hd__tapvpwrvgnd_1
XFILLER_14_41 VPWR VGND VPWR VGND sky130_ef_sc_hd__decap_12
XFILLER_14_85 VGND VGND VPWR VPWR sky130_fd_sc_hd__decap_4
XFILLER_30_73 VGND VGND VPWR VPWR sky130_fd_sc_hd__decap_3
XFILLER_5_279 VGND VGND VPWR VPWR sky130_fd_sc_hd__fill_1
XFILLER_1_441 VGND VGND VPWR VPWR sky130_fd_sc_hd__decap_6
XFILLER_17_353 VGND VGND VPWR VPWR sky130_fd_sc_hd__fill_1
XTAP_TAPCELL_ROW_19_315 VGND VPWR sky130_fd_sc_hd__tapvpwrvgnd_1
X_0972_ scratch\[6\]\[21\] scratch\[7\]\[21\] net272 VGND VGND VPWR VPWR _0713_ sky130_fd_sc_hd__mux2_1
XFILLER_32_356 VGND VGND VPWR VPWR sky130_fd_sc_hd__decap_8
XTAP_TAPCELL_ROW_27_381 VGND VPWR sky130_fd_sc_hd__tapvpwrvgnd_1
XFILLER_65_3 VPWR VGND VPWR VGND sky130_ef_sc_hd__decap_12
X_1524_ scratch\[3\]\[5\] scratch\[2\]\[5\] VGND VGND VPWR VPWR _0469_ sky130_fd_sc_hd__or2_1
XFILLER_67_231 VGND VGND VPWR VPWR sky130_fd_sc_hd__fill_1
XFILLER_67_220 VGND VGND VPWR VPWR sky130_fd_sc_hd__decap_4
X_1386_ scratch\[0\]\[13\] net148 _0384_ VGND VGND VPWR VPWR _0387_ sky130_fd_sc_hd__and3_1
X_1455_ net43 net157 net118 _0439_ VGND VGND VPWR VPWR _0200_ sky130_fd_sc_hd__a22o_1
XFILLER_67_297 VGND VGND VPWR VPWR sky130_fd_sc_hd__decap_8
XFILLER_50_120 VGND VGND VPWR VPWR sky130_fd_sc_hd__fill_2
XFILLER_23_312 VGND VGND VPWR VPWR sky130_fd_sc_hd__fill_2
XFILLER_51_39 VPWR VGND VPWR VGND sky130_ef_sc_hd__decap_12
XFILLER_50_197 VGND VGND VPWR VPWR sky130_fd_sc_hd__fill_2
XFILLER_73_223 VGND VGND VPWR VPWR sky130_fd_sc_hd__fill_1
XFILLER_58_253 VGND VGND VPWR VPWR sky130_fd_sc_hd__decap_4
XFILLER_61_429 VPWR VGND VPWR VGND sky130_ef_sc_hd__decap_12
XFILLER_41_164 VGND VGND VPWR VPWR sky130_fd_sc_hd__decap_4
XFILLER_26_194 VGND VGND VPWR VPWR sky130_fd_sc_hd__fill_2
XFILLER_25_51 VGND VGND VPWR VPWR sky130_fd_sc_hd__decap_4
XFILLER_14_389 VPWR VGND VPWR VGND sky130_ef_sc_hd__decap_12
XFILLER_41_94 VGND VGND VPWR VPWR sky130_fd_sc_hd__decap_4
X_1171_ net385 net125 _0808_ VGND VGND VPWR VPWR _0093_ sky130_fd_sc_hd__a21o_1
XFILLER_2_77 VGND VGND VPWR VPWR sky130_fd_sc_hd__decap_6
XFILLER_1_293 VPWR VGND VPWR VGND sky130_ef_sc_hd__decap_12
X_1240_ net237 net170 scratch\[6\]\[30\] VGND VGND VPWR VPWR _0298_ sky130_fd_sc_hd__or3b_1
XTAP_TAPCELL_ROW_75_774 VGND VPWR sky130_fd_sc_hd__tapvpwrvgnd_1
XTAP_TAPCELL_ROW_75_763 VGND VPWR sky130_fd_sc_hd__tapvpwrvgnd_1
XFILLER_64_289 VGND VGND VPWR VPWR sky130_fd_sc_hd__decap_3
XFILLER_52_429 VGND VGND VPWR VPWR sky130_fd_sc_hd__decap_8
X_0955_ scratch\[2\]\[19\] scratch\[3\]\[19\] net272 VGND VGND VPWR VPWR _0698_ sky130_fd_sc_hd__mux2_1
X_0886_ net255 _0639_ _0640_ VGND VGND VPWR VPWR _0641_ sky130_fd_sc_hd__a21o_1
XFILLER_9_393 VPWR VGND VPWR VGND sky130_ef_sc_hd__decap_12
Xoutput101 net101 VGND VGND VPWR VPWR host_output_data[4] sky130_fd_sc_hd__clkbuf_4
X_1507_ net278 net108 _0455_ VGND VGND VPWR VPWR _0236_ sky130_fd_sc_hd__a21o_1
XFILLER_55_223 VGND VGND VPWR VPWR sky130_fd_sc_hd__fill_1
X_1369_ net52 net154 net117 _0374_ VGND VGND VPWR VPWR _0179_ sky130_fd_sc_hd__a22o_1
XFILLER_28_415 VGND VGND VPWR VPWR sky130_fd_sc_hd__decap_4
XFILLER_28_404 VGND VGND VPWR VPWR sky130_fd_sc_hd__decap_3
X_1438_ net39 net157 net118 _0426_ VGND VGND VPWR VPWR _0196_ sky130_fd_sc_hd__a22o_1
XFILLER_62_27 VGND VGND VPWR VPWR sky130_fd_sc_hd__fill_1
XFILLER_55_289 VGND VGND VPWR VPWR sky130_fd_sc_hd__decap_4
XTAP_TAPCELL_ROW_38_465 VGND VPWR sky130_fd_sc_hd__tapvpwrvgnd_1
XFILLER_23_186 VGND VGND VPWR VPWR sky130_fd_sc_hd__fill_2
XFILLER_23_164 VGND VGND VPWR VPWR sky130_fd_sc_hd__decap_4
XFILLER_11_315 VPWR VGND VPWR VGND sky130_ef_sc_hd__decap_12
XFILLER_11_337 VPWR VGND VPWR VGND sky130_ef_sc_hd__decap_12
XFILLER_15_109 VGND VGND VPWR VPWR sky130_fd_sc_hd__decap_3
XTAP_TAPCELL_ROW_21_332 VGND VPWR sky130_fd_sc_hd__tapvpwrvgnd_1
Xinput25 host_input_data[12] VGND VGND VPWR VPWR net25 sky130_fd_sc_hd__clkbuf_2
XFILLER_52_93 VGND VGND VPWR VPWR sky130_fd_sc_hd__fill_2
Xinput36 host_input_data[22] VGND VGND VPWR VPWR net36 sky130_fd_sc_hd__buf_2
Xinput14 host_input_addr[2] VGND VGND VPWR VPWR net14 sky130_fd_sc_hd__clkbuf_1
XFILLER_14_197 VPWR VGND VPWR VGND sky130_ef_sc_hd__decap_12
Xinput47 host_input_data[3] VGND VGND VPWR VPWR net47 sky130_fd_sc_hd__buf_2
XFILLER_6_363 VGND VGND VPWR VPWR sky130_fd_sc_hd__fill_1
Xinput58 host_output_addr[2] VGND VGND VPWR VPWR net58 sky130_fd_sc_hd__clkbuf_1
XFILLER_69_337 VPWR VGND VPWR VGND sky130_ef_sc_hd__decap_12
X_1154_ net21 net196 net180 net53 VGND VGND VPWR VPWR _0800_ sky130_fd_sc_hd__a22o_1
X_1223_ net35 net176 _0289_ VGND VGND VPWR VPWR _0118_ sky130_fd_sc_hd__a21bo_1
XFILLER_37_223 VGND VGND VPWR VPWR sky130_fd_sc_hd__fill_1
XFILLER_37_212 VGND VGND VPWR VPWR sky130_fd_sc_hd__fill_1
XFILLER_60_292 VGND VGND VPWR VPWR sky130_fd_sc_hd__decap_4
XTAP_TAPCELL_ROW_35_446 VGND VPWR sky130_fd_sc_hd__tapvpwrvgnd_1
X_1085_ net46 net190 net133 net332 VGND VGND VPWR VPWR _0032_ sky130_fd_sc_hd__a22o_1
X_0869_ scratch\[0\]\[5\] scratch\[2\]\[5\] scratch\[1\]\[5\] scratch\[3\]\[5\] net255
+ net265 VGND VGND VPWR VPWR _0626_ sky130_fd_sc_hd__mux4_1
X_0938_ scratch\[0\]\[16\] scratch\[2\]\[16\] scratch\[1\]\[16\] scratch\[3\]\[16\]
+ net261 net271 VGND VGND VPWR VPWR _0684_ sky130_fd_sc_hd__mux4_1
XFILLER_20_145 VGND VGND VPWR VPWR sky130_fd_sc_hd__fill_1
XFILLER_20_167 VPWR VGND VPWR VGND sky130_ef_sc_hd__decap_12
XFILLER_57_27 VGND VGND VPWR VPWR sky130_fd_sc_hd__fill_2
XFILLER_73_15 VPWR VGND VPWR VGND sky130_ef_sc_hd__decap_12
XFILLER_43_259 VPWR VGND VPWR VGND sky130_ef_sc_hd__decap_12
XFILLER_28_223 VGND VGND VPWR VPWR sky130_fd_sc_hd__decap_6
XFILLER_51_281 VGND VGND VPWR VPWR sky130_fd_sc_hd__decap_6
XFILLER_7_105 VGND VGND VPWR VPWR sky130_fd_sc_hd__decap_6
XFILLER_22_41 VPWR VGND VPWR VGND sky130_ef_sc_hd__decap_12
XFILLER_7_149 VPWR VGND VPWR VGND sky130_ef_sc_hd__decap_12
XFILLER_22_85 VGND VGND VPWR VPWR sky130_fd_sc_hd__fill_2
XFILLER_66_307 VGND VGND VPWR VPWR sky130_fd_sc_hd__fill_1
Xfanout180 _0789_ VGND VGND VPWR VPWR net180 sky130_fd_sc_hd__clkbuf_2
Xfanout191 net192 VGND VGND VPWR VPWR net191 sky130_fd_sc_hd__buf_2
XFILLER_14_9 VPWR VGND VPWR VGND sky130_ef_sc_hd__decap_12
XFILLER_63_92 VPWR VGND VPWR VGND sky130_ef_sc_hd__decap_12
X_1910_ clknet_leaf_10_clock _0252_ VGND VGND VPWR VPWR scratch\[1\]\[17\] sky130_fd_sc_hd__dfxtp_1
XFILLER_34_215 VPWR VGND VPWR VGND sky130_ef_sc_hd__decap_12
XTAP_TAPCELL_ROW_32_416 VGND VPWR sky130_fd_sc_hd__tapvpwrvgnd_1
XFILLER_15_440 VGND VGND VPWR VPWR sky130_fd_sc_hd__decap_8
XFILLER_19_278 VGND VGND VPWR VPWR sky130_fd_sc_hd__fill_2
X_1841_ clknet_leaf_8_clock _0183_ VGND VGND VPWR VPWR scratch\[0\]\[12\] sky130_fd_sc_hd__dfxtp_1
XTAP_TAPCELL_ROW_40_482 VGND VPWR sky130_fd_sc_hd__tapvpwrvgnd_1
X_1772_ clknet_leaf_18_clock _0115_ VGND VGND VPWR VPWR scratch\[6\]\[18\] sky130_fd_sc_hd__dfxtp_1
XFILLER_8_65 VPWR VGND VPWR VGND sky130_ef_sc_hd__decap_12
XFILLER_69_167 VGND VGND VPWR VPWR sky130_fd_sc_hd__fill_1
X_1206_ net238 net169 scratch\[6\]\[13\] VGND VGND VPWR VPWR _0281_ sky130_fd_sc_hd__or3b_1
X_1137_ net379 net121 _0791_ VGND VGND VPWR VPWR _0076_ sky130_fd_sc_hd__a21o_1
X_1068_ net27 net189 net136 net356 VGND VGND VPWR VPWR _0015_ sky130_fd_sc_hd__a22o_1
XFILLER_33_281 VGND VGND VPWR VPWR sky130_fd_sc_hd__decap_6
XFILLER_25_259 VGND VGND VPWR VPWR sky130_fd_sc_hd__fill_1
XFILLER_21_421 VGND VGND VPWR VPWR sky130_fd_sc_hd__fill_2
XFILLER_68_15 VPWR VGND VPWR VGND sky130_ef_sc_hd__decap_12
XFILLER_75_137 VGND VGND VPWR VPWR sky130_fd_sc_hd__decap_3
XFILLER_0_325 VGND VGND VPWR VPWR sky130_fd_sc_hd__decap_8
XTAP_TAPCELL_ROW_54_596 VGND VPWR sky130_fd_sc_hd__tapvpwrvgnd_1
XTAP_TAPCELL_ROW_3_185 VGND VPWR sky130_fd_sc_hd__tapvpwrvgnd_1
XFILLER_17_52 VGND VGND VPWR VPWR sky130_fd_sc_hd__decap_4
XFILLER_62_321 VPWR VGND VPWR VGND sky130_ef_sc_hd__decap_12
Xhold3 scratch\[1\]\[17\] VGND VGND VPWR VPWR net279 sky130_fd_sc_hd__dlygate4sd3_1
XFILLER_12_6 VPWR VGND VPWR VGND sky130_ef_sc_hd__decap_12
XFILLER_30_273 VPWR VGND VPWR VGND sky130_ef_sc_hd__decap_12
XFILLER_30_251 VGND VGND VPWR VPWR sky130_fd_sc_hd__fill_1
XFILLER_30_240 VGND VGND VPWR VPWR sky130_fd_sc_hd__decap_3
XFILLER_15_281 VGND VGND VPWR VPWR sky130_fd_sc_hd__decap_4
XTAP_TAPCELL_ROW_17_298 VGND VPWR sky130_fd_sc_hd__tapvpwrvgnd_1
X_1824_ clknet_leaf_0_clock _0166_ VGND VGND VPWR VPWR cycle_count\[0\] sky130_fd_sc_hd__dfxtp_1
X_1755_ clknet_leaf_27_clock _0098_ VGND VGND VPWR VPWR scratch\[6\]\[1\] sky130_fd_sc_hd__dfxtp_1
X_1686_ clknet_leaf_21_clock _0029_ VGND VGND VPWR VPWR scratch\[4\]\[28\] sky130_fd_sc_hd__dfxtp_1
XFILLER_57_148 VGND VGND VPWR VPWR sky130_fd_sc_hd__decap_8
XFILLER_38_18 VGND VGND VPWR VPWR sky130_fd_sc_hd__decap_8
XTAP_TAPCELL_ROW_0_166 VGND VPWR sky130_fd_sc_hd__tapvpwrvgnd_1
XTAP_TAPCELL_ROW_0_155 VGND VPWR sky130_fd_sc_hd__tapvpwrvgnd_1
XFILLER_70_27 VGND VGND VPWR VPWR sky130_fd_sc_hd__fill_1
XFILLER_5_417 VPWR VGND VPWR VGND sky130_ef_sc_hd__decap_12
XTAP_TAPCELL_ROW_59_633 VGND VPWR sky130_fd_sc_hd__tapvpwrvgnd_1
XFILLER_44_321 VPWR VGND VPWR VGND sky130_ef_sc_hd__decap_12
XFILLER_28_62 VPWR VGND VPWR VGND sky130_ef_sc_hd__decap_12
XTAP_TAPCELL_ROW_42_500 VGND VPWR sky130_fd_sc_hd__tapvpwrvgnd_1
XTAP_TAPCELL_ROW_14_279 VGND VPWR sky130_fd_sc_hd__tapvpwrvgnd_1
X_1540_ net197 _0480_ _0481_ VGND VGND VPWR VPWR _0482_ sky130_fd_sc_hd__and3_1
XFILLER_8_233 VGND VGND VPWR VPWR sky130_fd_sc_hd__decap_6
X_1471_ net51 net143 net113 net437 VGND VGND VPWR VPWR _0210_ sky130_fd_sc_hd__a22o_1
XFILLER_39_137 VGND VGND VPWR VPWR sky130_fd_sc_hd__decap_6
XFILLER_62_151 VPWR VGND VPWR VGND sky130_ef_sc_hd__decap_12
XFILLER_54_107 VGND VGND VPWR VPWR sky130_fd_sc_hd__fill_1
XFILLER_35_343 VGND VGND VPWR VPWR sky130_fd_sc_hd__fill_1
X_1807_ clknet_leaf_13_clock _0150_ VGND VGND VPWR VPWR scratch\[7\]\[21\] sky130_fd_sc_hd__dfxtp_1
XFILLER_40_19 VGND VGND VPWR VPWR sky130_fd_sc_hd__decap_8
X_1669_ clknet_leaf_10_clock _0012_ VGND VGND VPWR VPWR scratch\[4\]\[11\] sky130_fd_sc_hd__dfxtp_1
X_1738_ clknet_leaf_4_clock _0081_ VGND VGND VPWR VPWR scratch\[2\]\[5\] sky130_fd_sc_hd__dfxtp_1
XFILLER_49_39 VPWR VGND VPWR VGND sky130_ef_sc_hd__decap_12
XTAP_TAPCELL_ROW_5_203 VGND VPWR sky130_fd_sc_hd__tapvpwrvgnd_1
XFILLER_73_449 VGND VGND VPWR VPWR sky130_fd_sc_hd__decap_4
XFILLER_73_405 VPWR VGND VPWR VGND sky130_ef_sc_hd__decap_12
XFILLER_65_27 VPWR VGND VPWR VGND sky130_ef_sc_hd__decap_12
XTAP_TAPCELL_ROW_56_614 VGND VPWR sky130_fd_sc_hd__tapvpwrvgnd_1
XFILLER_41_302 VGND VGND VPWR VPWR sky130_fd_sc_hd__decap_4
XFILLER_14_53 VGND VGND VPWR VPWR sky130_fd_sc_hd__decap_8
XFILLER_30_41 VGND VGND VPWR VPWR sky130_fd_sc_hd__fill_1
XFILLER_5_225 VPWR VGND VPWR VGND sky130_ef_sc_hd__decap_12
XTAP_TAPCELL_ROW_11_249 VGND VPWR sky130_fd_sc_hd__tapvpwrvgnd_1
XFILLER_49_424 VPWR VGND VPWR VGND sky130_ef_sc_hd__decap_12
XFILLER_36_129 VGND VGND VPWR VPWR sky130_fd_sc_hd__decap_6
XTAP_TAPCELL_ROW_19_316 VGND VPWR sky130_fd_sc_hd__tapvpwrvgnd_1
XFILLER_71_81 VPWR VGND VPWR VGND sky130_ef_sc_hd__decap_12
X_0971_ scratch\[1\]\[21\] net220 _0711_ VGND VGND VPWR VPWR _0712_ sky130_fd_sc_hd__a21o_1
XTAP_TAPCELL_ROW_27_382 VGND VPWR sky130_fd_sc_hd__tapvpwrvgnd_1
XFILLER_58_3 VPWR VGND VPWR VGND sky130_ef_sc_hd__decap_12
X_1523_ scratch\[3\]\[5\] scratch\[2\]\[5\] VGND VGND VPWR VPWR _0468_ sky130_fd_sc_hd__nand2_1
X_1454_ scratch\[0\]\[29\] _0436_ _0438_ _0348_ VGND VGND VPWR VPWR _0439_ sky130_fd_sc_hd__o22a_1
XFILLER_55_449 VGND VGND VPWR VPWR sky130_fd_sc_hd__decap_4
XFILLER_55_427 VPWR VGND VPWR VGND sky130_ef_sc_hd__decap_12
X_1385_ net148 _0384_ scratch\[0\]\[13\] VGND VGND VPWR VPWR _0386_ sky130_fd_sc_hd__a21oi_1
XFILLER_70_419 VGND VGND VPWR VPWR sky130_fd_sc_hd__fill_1
XTAP_TAPCELL_ROW_61_650 VGND VPWR sky130_fd_sc_hd__tapvpwrvgnd_1
XFILLER_35_173 VGND VGND VPWR VPWR sky130_fd_sc_hd__decap_6
XFILLER_23_346 VGND VGND VPWR VPWR sky130_fd_sc_hd__decap_8
XFILLER_23_335 VGND VGND VPWR VPWR sky130_fd_sc_hd__fill_1
XFILLER_73_279 VGND VGND VPWR VPWR sky130_fd_sc_hd__fill_1
XFILLER_18_107 VGND VGND VPWR VPWR sky130_fd_sc_hd__decap_6
XFILLER_41_187 VPWR VGND VPWR VGND sky130_ef_sc_hd__decap_12
XFILLER_41_154 VGND VGND VPWR VPWR sky130_fd_sc_hd__decap_3
XTAP_TAPCELL_ROW_24_352 VGND VPWR sky130_fd_sc_hd__tapvpwrvgnd_1
X_1170_ net9 net202 net183 net30 VGND VGND VPWR VPWR _0808_ sky130_fd_sc_hd__a22o_1
XFILLER_37_449 VGND VGND VPWR VPWR sky130_fd_sc_hd__fill_1
XFILLER_37_405 VGND VGND VPWR VPWR sky130_fd_sc_hd__decap_4
XFILLER_1_261 VPWR VGND VPWR VGND sky130_ef_sc_hd__decap_12
XTAP_TAPCELL_ROW_75_775 VGND VPWR sky130_fd_sc_hd__tapvpwrvgnd_1
XTAP_TAPCELL_ROW_75_764 VGND VPWR sky130_fd_sc_hd__tapvpwrvgnd_1
X_0885_ scratch\[4\]\[7\] net223 net214 scratch\[5\]\[7\] net232 VGND VGND VPWR VPWR
+ _0640_ sky130_fd_sc_hd__a221o_1
X_0954_ net208 _0694_ _0697_ VGND VGND VPWR VPWR net84 sky130_fd_sc_hd__and3_1
XFILLER_32_176 VPWR VGND VPWR VGND sky130_ef_sc_hd__decap_12
XFILLER_9_361 VPWR VGND VPWR VGND sky130_ef_sc_hd__decap_12
Xoutput102 net102 VGND VGND VPWR VPWR host_output_data[5] sky130_fd_sc_hd__clkbuf_4
X_1437_ _0579_ _0348_ _0425_ _0423_ scratch\[0\]\[25\] VGND VGND VPWR VPWR _0426_
+ sky130_fd_sc_hd__o32a_1
X_1506_ net33 _0454_ net137 VGND VGND VPWR VPWR _0455_ sky130_fd_sc_hd__mux2_1
X_1368_ scratch\[0\]\[8\] _0372_ VGND VGND VPWR VPWR _0374_ sky130_fd_sc_hd__xnor2_1
XTAP_TAPCELL_ROW_38_466 VGND VPWR sky130_fd_sc_hd__tapvpwrvgnd_1
X_1299_ net247 net168 scratch\[7\]\[27\] VGND VGND VPWR VPWR _0328_ sky130_fd_sc_hd__or3b_1
XFILLER_11_327 VGND VGND VPWR VPWR sky130_fd_sc_hd__decap_8
XFILLER_11_349 VPWR VGND VPWR VGND sky130_ef_sc_hd__decap_12
XTAP_TAPCELL_ROW_21_333 VGND VPWR sky130_fd_sc_hd__tapvpwrvgnd_1
XFILLER_61_216 VGND VGND VPWR VPWR sky130_fd_sc_hd__decap_8
XFILLER_54_290 VGND VGND VPWR VPWR sky130_fd_sc_hd__decap_8
XFILLER_36_95 VGND VGND VPWR VPWR sky130_fd_sc_hd__fill_1
XFILLER_14_154 VPWR VGND VPWR VGND sky130_ef_sc_hd__decap_12
XFILLER_19_449 VGND VGND VPWR VPWR sky130_fd_sc_hd__decap_4
XFILLER_52_83 VGND VGND VPWR VPWR sky130_fd_sc_hd__fill_1
Xinput37 host_input_data[23] VGND VGND VPWR VPWR net37 sky130_fd_sc_hd__clkbuf_2
Xinput26 host_input_data[13] VGND VGND VPWR VPWR net26 sky130_fd_sc_hd__buf_2
Xinput48 host_input_data[4] VGND VGND VPWR VPWR net48 sky130_fd_sc_hd__buf_2
Xinput15 host_input_addr[3] VGND VGND VPWR VPWR net15 sky130_fd_sc_hd__buf_1
Xinput59 host_output_addr[3] VGND VGND VPWR VPWR net59 sky130_fd_sc_hd__clkbuf_1
XFILLER_69_349 VPWR VGND VPWR VGND sky130_ef_sc_hd__decap_12
XFILLER_69_305 VPWR VGND VPWR VGND sky130_ef_sc_hd__decap_12
X_1153_ net384 net122 _0799_ VGND VGND VPWR VPWR _0084_ sky130_fd_sc_hd__a21o_1
X_1222_ net246 net176 scratch\[6\]\[21\] VGND VGND VPWR VPWR _0289_ sky130_fd_sc_hd__or3b_1
XFILLER_37_235 VGND VGND VPWR VPWR sky130_fd_sc_hd__decap_8
X_1084_ net45 net190 net133 net336 VGND VGND VPWR VPWR _0031_ sky130_fd_sc_hd__a22o_1
XTAP_TAPCELL_ROW_35_447 VGND VPWR sky130_fd_sc_hd__tapvpwrvgnd_1
XFILLER_20_102 VGND VGND VPWR VPWR sky130_fd_sc_hd__decap_6
X_0868_ net206 _0622_ _0625_ _0601_ net73 VGND VGND VPWR VPWR net101 sky130_fd_sc_hd__a32o_1
X_0937_ net208 _0680_ _0683_ VGND VGND VPWR VPWR net81 sky130_fd_sc_hd__and3_1
XFILLER_20_179 VGND VGND VPWR VPWR sky130_fd_sc_hd__decap_3
XFILLER_73_27 VPWR VGND VPWR VGND sky130_ef_sc_hd__decap_12
XFILLER_43_216 VGND VGND VPWR VPWR sky130_fd_sc_hd__decap_8
XFILLER_28_235 VPWR VGND VPWR VGND sky130_ef_sc_hd__decap_12
XFILLER_16_408 VGND VGND VPWR VPWR sky130_fd_sc_hd__fill_1
XFILLER_11_113 VPWR VGND VPWR VGND sky130_ef_sc_hd__decap_12
XFILLER_74_363 VGND VGND VPWR VPWR sky130_fd_sc_hd__fill_1
Xfanout192 net193 VGND VGND VPWR VPWR net192 sky130_fd_sc_hd__buf_2
Xfanout181 net183 VGND VGND VPWR VPWR net181 sky130_fd_sc_hd__clkbuf_4
XFILLER_34_205 VGND VGND VPWR VPWR sky130_fd_sc_hd__decap_3
Xfanout170 net173 VGND VGND VPWR VPWR net170 sky130_fd_sc_hd__dlymetal6s2s_1
X_1840_ clknet_leaf_9_clock _0182_ VGND VGND VPWR VPWR scratch\[0\]\[11\] sky130_fd_sc_hd__dfxtp_1
XFILLER_42_282 VGND VGND VPWR VPWR sky130_fd_sc_hd__fill_2
XFILLER_34_227 VGND VGND VPWR VPWR sky130_fd_sc_hd__fill_2
XTAP_TAPCELL_ROW_32_417 VGND VPWR sky130_fd_sc_hd__tapvpwrvgnd_1
XFILLER_30_400 VGND VGND VPWR VPWR sky130_fd_sc_hd__fill_2
X_1771_ clknet_leaf_11_clock _0114_ VGND VGND VPWR VPWR scratch\[6\]\[17\] sky130_fd_sc_hd__dfxtp_1
XTAP_TAPCELL_ROW_40_483 VGND VPWR sky130_fd_sc_hd__tapvpwrvgnd_1
XFILLER_8_77 VGND VGND VPWR VPWR sky130_fd_sc_hd__decap_6
XFILLER_69_113 VPWR VGND VPWR VGND sky130_ef_sc_hd__decap_12
X_1205_ net25 net177 _0280_ VGND VGND VPWR VPWR _0109_ sky130_fd_sc_hd__a21bo_1
XTAP_TAPCELL_ROW_48_550 VGND VPWR sky130_fd_sc_hd__tapvpwrvgnd_1
X_1067_ net26 net193 net132 net335 VGND VGND VPWR VPWR _0014_ sky130_fd_sc_hd__a22o_1
X_1136_ net1 net195 net179 net22 VGND VGND VPWR VPWR _0791_ sky130_fd_sc_hd__a22o_1
XFILLER_33_260 VGND VGND VPWR VPWR sky130_fd_sc_hd__decap_3
XFILLER_68_27 VGND VGND VPWR VPWR sky130_fd_sc_hd__fill_1
XFILLER_4_109 VPWR VGND VPWR VGND sky130_ef_sc_hd__decap_12
XTAP_TAPCELL_ROW_3_186 VGND VPWR sky130_fd_sc_hd__tapvpwrvgnd_1
XTAP_TAPCELL_ROW_54_597 VGND VPWR sky130_fd_sc_hd__tapvpwrvgnd_1
XFILLER_58_60 VGND VGND VPWR VPWR sky130_fd_sc_hd__fill_1
Xhold4 scratch\[1\]\[24\] VGND VGND VPWR VPWR net280 sky130_fd_sc_hd__dlygate4sd3_1
XFILLER_62_333 VGND VGND VPWR VPWR sky130_fd_sc_hd__decap_8
XTAP_TAPCELL_ROW_45_520 VGND VPWR sky130_fd_sc_hd__tapvpwrvgnd_1
XFILLER_30_285 VGND VGND VPWR VPWR sky130_fd_sc_hd__decap_3
X_1823_ clknet_leaf_29_clock _0165_ VGND VGND VPWR VPWR net73 sky130_fd_sc_hd__dfxtp_1
XFILLER_15_271 VGND VGND VPWR VPWR sky130_fd_sc_hd__decap_8
XTAP_TAPCELL_ROW_17_299 VGND VPWR sky130_fd_sc_hd__tapvpwrvgnd_1
X_1685_ clknet_leaf_19_clock _0028_ VGND VGND VPWR VPWR scratch\[4\]\[27\] sky130_fd_sc_hd__dfxtp_1
X_1754_ clknet_leaf_26_clock _0097_ VGND VGND VPWR VPWR scratch\[6\]\[0\] sky130_fd_sc_hd__dfxtp_1
XFILLER_54_29 VPWR VGND VPWR VGND sky130_ef_sc_hd__decap_12
XFILLER_53_322 VGND VGND VPWR VPWR sky130_fd_sc_hd__decap_6
XTAP_TAPCELL_ROW_0_167 VGND VPWR sky130_fd_sc_hd__tapvpwrvgnd_1
XTAP_TAPCELL_ROW_0_156 VGND VPWR sky130_fd_sc_hd__tapvpwrvgnd_1
X_1119_ net43 net184 net127 net331 VGND VGND VPWR VPWR _0062_ sky130_fd_sc_hd__a22o_1
XFILLER_5_429 VPWR VGND VPWR VGND sky130_ef_sc_hd__decap_12
XPHY_EDGE_ROW_17_Right_17 VGND VGND VPWR VPWR sky130_fd_sc_hd__decap_3
XFILLER_21_285 VGND VGND VPWR VPWR sky130_fd_sc_hd__fill_1
XPHY_EDGE_ROW_26_Right_26 VGND VGND VPWR VPWR sky130_fd_sc_hd__decap_3
XFILLER_0_145 VGND VGND VPWR VPWR sky130_fd_sc_hd__fill_1
XFILLER_0_178 VGND VGND VPWR VPWR sky130_fd_sc_hd__decap_8
XTAP_TAPCELL_ROW_59_634 VGND VPWR sky130_fd_sc_hd__tapvpwrvgnd_1
XFILLER_56_182 VPWR VGND VPWR VGND sky130_ef_sc_hd__decap_12
XFILLER_44_333 VPWR VGND VPWR VGND sky130_ef_sc_hd__decap_12
XFILLER_28_85 VPWR VGND VPWR VGND sky130_ef_sc_hd__decap_12
XFILLER_28_74 VGND VGND VPWR VPWR sky130_fd_sc_hd__decap_8
XFILLER_44_40 VGND VGND VPWR VPWR sky130_fd_sc_hd__decap_4
XTAP_TAPCELL_ROW_42_501 VGND VPWR sky130_fd_sc_hd__tapvpwrvgnd_1
XPHY_EDGE_ROW_35_Right_35 VGND VGND VPWR VPWR sky130_fd_sc_hd__decap_3
XFILLER_12_285 VPWR VGND VPWR VGND sky130_ef_sc_hd__decap_12
XFILLER_60_83 VGND VGND VPWR VPWR sky130_fd_sc_hd__fill_1
X_1470_ net50 net142 net112 net404 VGND VGND VPWR VPWR _0209_ sky130_fd_sc_hd__a22o_1
XFILLER_69_81 VPWR VGND VPWR VGND sky130_ef_sc_hd__decap_12
XFILLER_67_447 VGND VGND VPWR VPWR sky130_fd_sc_hd__fill_1
XPHY_EDGE_ROW_44_Right_44 VGND VGND VPWR VPWR sky130_fd_sc_hd__decap_3
XFILLER_62_163 VGND VGND VPWR VPWR sky130_fd_sc_hd__decap_6
XFILLER_62_141 VGND VGND VPWR VPWR sky130_fd_sc_hd__fill_1
XPHY_EDGE_ROW_53_Right_53 VGND VGND VPWR VPWR sky130_fd_sc_hd__decap_3
XFILLER_50_325 VPWR VGND VPWR VGND sky130_ef_sc_hd__decap_12
XFILLER_35_399 VGND VGND VPWR VPWR sky130_fd_sc_hd__fill_1
X_1806_ clknet_leaf_13_clock _0149_ VGND VGND VPWR VPWR scratch\[7\]\[20\] sky130_fd_sc_hd__dfxtp_1
XPHY_EDGE_ROW_28_Left_104 VGND VGND VPWR VPWR sky130_fd_sc_hd__decap_3
XPHY_EDGE_ROW_62_Right_62 VGND VGND VPWR VPWR sky130_fd_sc_hd__decap_3
X_1599_ scratch\[3\]\[20\] scratch\[2\]\[20\] VGND VGND VPWR VPWR _0529_ sky130_fd_sc_hd__or2_1
X_1668_ clknet_leaf_8_clock _0011_ VGND VGND VPWR VPWR scratch\[4\]\[10\] sky130_fd_sc_hd__dfxtp_1
XPHY_EDGE_ROW_37_Left_113 VGND VGND VPWR VPWR sky130_fd_sc_hd__decap_3
X_1737_ clknet_leaf_1_clock _0080_ VGND VGND VPWR VPWR scratch\[2\]\[4\] sky130_fd_sc_hd__dfxtp_1
XTAP_TAPCELL_ROW_5_204 VGND VPWR sky130_fd_sc_hd__tapvpwrvgnd_1
XFILLER_73_417 VPWR VGND VPWR VGND sky130_ef_sc_hd__decap_12
XFILLER_65_39 VPWR VGND VPWR VGND sky130_ef_sc_hd__decap_12
XTAP_TAPCELL_ROW_56_615 VGND VPWR sky130_fd_sc_hd__tapvpwrvgnd_1
XFILLER_26_344 VGND VGND VPWR VPWR sky130_fd_sc_hd__decap_3
XPHY_EDGE_ROW_71_Right_71 VGND VGND VPWR VPWR sky130_fd_sc_hd__decap_3
XPHY_EDGE_ROW_46_Left_122 VGND VGND VPWR VPWR sky130_fd_sc_hd__decap_3
XFILLER_14_21 VGND VGND VPWR VPWR sky130_fd_sc_hd__decap_6
XFILLER_5_237 VPWR VGND VPWR VGND sky130_ef_sc_hd__decap_12
XPHY_EDGE_ROW_55_Left_131 VGND VGND VPWR VPWR sky130_fd_sc_hd__decap_3
XFILLER_49_447 VGND VGND VPWR VPWR sky130_fd_sc_hd__fill_1
XFILLER_49_436 VGND VGND VPWR VPWR sky130_fd_sc_hd__decap_4
XPHY_EDGE_ROW_64_Left_140 VGND VGND VPWR VPWR sky130_fd_sc_hd__decap_3
XFILLER_44_141 VPWR VGND VPWR VGND sky130_ef_sc_hd__decap_12
XTAP_TAPCELL_ROW_27_383 VGND VPWR sky130_fd_sc_hd__tapvpwrvgnd_1
XFILLER_17_333 VGND VGND VPWR VPWR sky130_fd_sc_hd__decap_3
XFILLER_17_366 VPWR VGND VPWR VGND sky130_ef_sc_hd__decap_12
XTAP_TAPCELL_ROW_19_317 VGND VPWR sky130_fd_sc_hd__tapvpwrvgnd_1
XFILLER_71_93 VPWR VGND VPWR VGND sky130_ef_sc_hd__decap_12
X_0970_ scratch\[0\]\[21\] net229 _0710_ net260 net252 VGND VGND VPWR VPWR _0711_
+ sky130_fd_sc_hd__a221o_1
X_1522_ net310 net107 _0467_ VGND VGND VPWR VPWR _0239_ sky130_fd_sc_hd__a21o_1
X_1453_ scratch\[0\]\[28\] scratch\[0\]\[29\] _0433_ VGND VGND VPWR VPWR _0438_ sky130_fd_sc_hd__nand3_1
XFILLER_55_439 VGND VGND VPWR VPWR sky130_fd_sc_hd__decap_8
X_1384_ net25 net156 net118 _0385_ VGND VGND VPWR VPWR _0183_ sky130_fd_sc_hd__a22o_1
XTAP_TAPCELL_ROW_61_651 VGND VPWR sky130_fd_sc_hd__tapvpwrvgnd_1
XFILLER_50_166 VPWR VGND VPWR VGND sky130_ef_sc_hd__decap_12
XFILLER_50_155 VGND VGND VPWR VPWR sky130_fd_sc_hd__decap_3
XFILLER_50_100 VPWR VGND VPWR VGND sky130_ef_sc_hd__decap_12
XFILLER_35_141 VGND VGND VPWR VPWR sky130_fd_sc_hd__decap_3
XFILLER_73_225 VPWR VGND VPWR VGND sky130_ef_sc_hd__decap_12
XFILLER_58_277 VPWR VGND VPWR VGND sky130_ef_sc_hd__decap_12
XFILLER_54_450 VGND VGND VPWR VPWR sky130_fd_sc_hd__decap_3
XFILLER_26_130 VGND VGND VPWR VPWR sky130_fd_sc_hd__fill_1
XFILLER_14_303 VGND VGND VPWR VPWR sky130_fd_sc_hd__decap_4
XFILLER_14_325 VGND VGND VPWR VPWR sky130_fd_sc_hd__fill_1
XFILLER_14_336 VPWR VGND VPWR VGND sky130_ef_sc_hd__decap_12
XFILLER_41_63 VPWR VGND VPWR VGND sky130_ef_sc_hd__decap_12
XFILLER_41_52 VGND VGND VPWR VPWR sky130_fd_sc_hd__decap_4
XTAP_TAPCELL_ROW_24_353 VGND VPWR sky130_fd_sc_hd__tapvpwrvgnd_1
XFILLER_22_391 VGND VGND VPWR VPWR sky130_fd_sc_hd__decap_3
XFILLER_1_273 VGND VGND VPWR VPWR sky130_fd_sc_hd__decap_6
XTAP_TAPCELL_ROW_75_765 VGND VPWR sky130_fd_sc_hd__tapvpwrvgnd_1
XFILLER_32_188 VGND VGND VPWR VPWR sky130_fd_sc_hd__fill_2
XFILLER_70_3 VPWR VGND VPWR VGND sky130_ef_sc_hd__decap_12
X_0884_ scratch\[6\]\[7\] scratch\[7\]\[7\] net265 VGND VGND VPWR VPWR _0639_ sky130_fd_sc_hd__mux2_1
Xoutput103 net103 VGND VGND VPWR VPWR host_output_data[6] sky130_fd_sc_hd__clkbuf_4
X_0953_ net259 _0695_ _0696_ VGND VGND VPWR VPWR _0697_ sky130_fd_sc_hd__a21o_1
XFILLER_9_373 VPWR VGND VPWR VGND sky130_ef_sc_hd__decap_12
XFILLER_13_391 VGND VGND VPWR VPWR sky130_fd_sc_hd__fill_1
X_1367_ net51 net154 _0373_ VGND VGND VPWR VPWR _0178_ sky130_fd_sc_hd__a21o_1
X_1436_ scratch\[0\]\[25\] _0421_ VGND VGND VPWR VPWR _0425_ sky130_fd_sc_hd__nand2_1
X_1505_ net194 _0452_ _0453_ VGND VGND VPWR VPWR _0454_ sky130_fd_sc_hd__and3_1
XFILLER_55_225 VGND VGND VPWR VPWR sky130_fd_sc_hd__decap_8
XFILLER_46_19 VGND VGND VPWR VPWR sky130_fd_sc_hd__fill_1
XTAP_TAPCELL_ROW_38_467 VGND VPWR sky130_fd_sc_hd__tapvpwrvgnd_1
X_1298_ net40 net164 _0327_ VGND VGND VPWR VPWR _0155_ sky130_fd_sc_hd__a21bo_1
XFILLER_62_29 VPWR VGND VPWR VGND sky130_ef_sc_hd__decap_12
XFILLER_23_177 VGND VGND VPWR VPWR sky130_fd_sc_hd__decap_3
XTAP_TAPCELL_ROW_21_334 VGND VPWR sky130_fd_sc_hd__tapvpwrvgnd_1
XFILLER_36_85 VGND VGND VPWR VPWR sky130_fd_sc_hd__fill_1
XFILLER_36_41 VGND VGND VPWR VPWR sky130_fd_sc_hd__fill_1
XFILLER_14_166 VGND VGND VPWR VPWR sky130_fd_sc_hd__decap_6
Xinput27 host_input_data[14] VGND VGND VPWR VPWR net27 sky130_fd_sc_hd__buf_2
Xinput49 host_input_data[5] VGND VGND VPWR VPWR net49 sky130_fd_sc_hd__clkbuf_2
Xinput16 host_input_addr[4] VGND VGND VPWR VPWR net16 sky130_fd_sc_hd__buf_1
Xinput38 host_input_data[24] VGND VGND VPWR VPWR net38 sky130_fd_sc_hd__clkbuf_2
XFILLER_6_321 VPWR VGND VPWR VGND sky130_ef_sc_hd__decap_12
XFILLER_6_365 VPWR VGND VPWR VGND sky130_ef_sc_hd__decap_12
XFILLER_10_361 VGND VGND VPWR VPWR sky130_fd_sc_hd__decap_3
XFILLER_69_317 VPWR VGND VPWR VGND sky130_ef_sc_hd__decap_12
X_1221_ net34 net176 _0288_ VGND VGND VPWR VPWR _0117_ sky130_fd_sc_hd__a21bo_1
XFILLER_35_6 VGND VGND VPWR VPWR sky130_fd_sc_hd__decap_8
X_1152_ net20 net196 net180 net52 VGND VGND VPWR VPWR _0799_ sky130_fd_sc_hd__a22o_1
XFILLER_37_258 VPWR VGND VPWR VGND sky130_ef_sc_hd__decap_12
XFILLER_37_225 VGND VGND VPWR VPWR sky130_fd_sc_hd__decap_3
X_1083_ net43 net190 net133 net325 VGND VGND VPWR VPWR _0030_ sky130_fd_sc_hd__a22o_1
XFILLER_60_261 VGND VGND VPWR VPWR sky130_fd_sc_hd__fill_2
X_0936_ net258 _0681_ _0682_ VGND VGND VPWR VPWR _0683_ sky130_fd_sc_hd__a21o_1
X_0867_ scratch\[5\]\[4\] net213 _0624_ VGND VGND VPWR VPWR _0625_ sky130_fd_sc_hd__a21o_1
X_1419_ scratch\[0\]\[18\] scratch\[0\]\[19\] scratch\[0\]\[20\] scratch\[0\]\[21\]
+ VGND VGND VPWR VPWR _0412_ sky130_fd_sc_hd__and4_1
XFILLER_28_247 VGND VGND VPWR VPWR sky130_fd_sc_hd__decap_4
XFILLER_73_39 VPWR VGND VPWR VGND sky130_ef_sc_hd__decap_12
XFILLER_11_125 VGND VGND VPWR VPWR sky130_fd_sc_hd__decap_8
XFILLER_11_158 VGND VGND VPWR VPWR sky130_fd_sc_hd__decap_8
XFILLER_11_169 VGND VGND VPWR VPWR sky130_fd_sc_hd__decap_6
XFILLER_22_65 VGND VGND VPWR VPWR sky130_fd_sc_hd__decap_6
XFILLER_66_309 VGND VGND VPWR VPWR sky130_fd_sc_hd__decap_8
XFILLER_3_335 VGND VGND VPWR VPWR sky130_fd_sc_hd__fill_1
XFILLER_0_3 VPWR VGND VPWR VGND sky130_ef_sc_hd__decap_12
Xfanout171 net173 VGND VGND VPWR VPWR net171 sky130_fd_sc_hd__clkbuf_2
Xfanout193 _0778_ VGND VGND VPWR VPWR net193 sky130_fd_sc_hd__buf_2
Xfanout182 net183 VGND VGND VPWR VPWR net182 sky130_fd_sc_hd__clkbuf_2
Xfanout160 net163 VGND VGND VPWR VPWR net160 sky130_fd_sc_hd__dlymetal6s2s_1
XFILLER_15_420 VGND VGND VPWR VPWR sky130_fd_sc_hd__fill_1
XFILLER_19_225 VGND VGND VPWR VPWR sky130_fd_sc_hd__decap_8
X_1770_ clknet_leaf_9_clock _0113_ VGND VGND VPWR VPWR scratch\[6\]\[16\] sky130_fd_sc_hd__dfxtp_1
XTAP_TAPCELL_ROW_32_418 VGND VPWR sky130_fd_sc_hd__tapvpwrvgnd_1
XTAP_TAPCELL_ROW_40_484 VGND VPWR sky130_fd_sc_hd__tapvpwrvgnd_1
XFILLER_6_195 VGND VGND VPWR VPWR sky130_fd_sc_hd__fill_1
XFILLER_10_191 VGND VGND VPWR VPWR sky130_fd_sc_hd__decap_4
XFILLER_69_169 VGND VGND VPWR VPWR sky130_fd_sc_hd__fill_1
XFILLER_69_125 VPWR VGND VPWR VGND sky130_ef_sc_hd__decap_12
X_1204_ net245 net177 scratch\[6\]\[12\] VGND VGND VPWR VPWR _0280_ sky130_fd_sc_hd__or3b_1
X_1066_ net25 net191 net134 net342 VGND VGND VPWR VPWR _0013_ sky130_fd_sc_hd__a22o_1
XTAP_TAPCELL_ROW_48_551 VGND VPWR sky130_fd_sc_hd__tapvpwrvgnd_1
X_1135_ net46 net179 net121 net397 VGND VGND VPWR VPWR _0075_ sky130_fd_sc_hd__a22o_1
XFILLER_25_206 VPWR VGND VPWR VGND sky130_ef_sc_hd__decap_12
X_1899_ clknet_leaf_4_clock _0241_ VGND VGND VPWR VPWR scratch\[1\]\[6\] sky130_fd_sc_hd__dfxtp_1
X_0919_ scratch\[2\]\[13\] scratch\[3\]\[13\] net267 VGND VGND VPWR VPWR _0668_ sky130_fd_sc_hd__mux2_1
XFILLER_0_305 VGND VGND VPWR VPWR sky130_fd_sc_hd__decap_3
XFILLER_68_191 VGND VGND VPWR VPWR sky130_fd_sc_hd__decap_4
XFILLER_56_342 VGND VGND VPWR VPWR sky130_fd_sc_hd__decap_8
XTAP_TAPCELL_ROW_3_187 VGND VPWR sky130_fd_sc_hd__tapvpwrvgnd_1
XTAP_TAPCELL_ROW_54_598 VGND VPWR sky130_fd_sc_hd__tapvpwrvgnd_1
XFILLER_12_401 VPWR VGND VPWR VGND sky130_ef_sc_hd__decap_12
XFILLER_17_98 VGND VGND VPWR VPWR sky130_fd_sc_hd__decap_4
XFILLER_66_139 VGND VGND VPWR VPWR sky130_fd_sc_hd__fill_1
Xhold5 scratch\[1\]\[26\] VGND VGND VPWR VPWR net281 sky130_fd_sc_hd__dlygate4sd3_1
XFILLER_62_301 VGND VGND VPWR VPWR sky130_fd_sc_hd__decap_6
XTAP_TAPCELL_ROW_45_521 VGND VPWR sky130_fd_sc_hd__tapvpwrvgnd_1
XFILLER_15_261 VGND VGND VPWR VPWR sky130_fd_sc_hd__decap_3
X_1753_ clknet_leaf_13_clock _0096_ VGND VGND VPWR VPWR scratch\[2\]\[20\] sky130_fd_sc_hd__dfxtp_1
X_1822_ clknet_leaf_29_clock _0164_ VGND VGND VPWR VPWR net72 sky130_fd_sc_hd__dfxtp_1
X_1684_ clknet_leaf_19_clock _0027_ VGND VGND VPWR VPWR scratch\[4\]\[26\] sky130_fd_sc_hd__dfxtp_1
XFILLER_72_109 VPWR VGND VPWR VGND sky130_ef_sc_hd__decap_12
XPHY_EDGE_ROW_13_Left_89 VGND VGND VPWR VPWR sky130_fd_sc_hd__decap_3
XFILLER_70_29 VPWR VGND VPWR VGND sky130_ef_sc_hd__decap_12
XTAP_TAPCELL_ROW_51_568 VGND VPWR sky130_fd_sc_hd__tapvpwrvgnd_1
X_1049_ net236 net18 VGND VGND VPWR VPWR _0779_ sky130_fd_sc_hd__or2_1
XTAP_TAPCELL_ROW_0_157 VGND VPWR sky130_fd_sc_hd__tapvpwrvgnd_1
X_1118_ net42 net187 net130 net359 VGND VGND VPWR VPWR _0061_ sky130_fd_sc_hd__a22o_1
XTAP_TAPCELL_ROW_59_635 VGND VPWR sky130_fd_sc_hd__tapvpwrvgnd_1
XFILLER_48_139 VGND VGND VPWR VPWR sky130_fd_sc_hd__fill_1
XFILLER_0_113 VPWR VGND VPWR VGND sky130_ef_sc_hd__decap_12
XTAP_TAPCELL_ROW_8_224 VGND VPWR sky130_fd_sc_hd__tapvpwrvgnd_1
XFILLER_56_194 VGND VGND VPWR VPWR sky130_fd_sc_hd__fill_2
XFILLER_44_345 VGND VGND VPWR VPWR sky130_fd_sc_hd__decap_3
XTAP_TAPCELL_ROW_42_502 VGND VPWR sky130_fd_sc_hd__tapvpwrvgnd_1
XFILLER_28_97 VGND VGND VPWR VPWR sky130_fd_sc_hd__decap_8
XFILLER_12_253 VGND VGND VPWR VPWR sky130_fd_sc_hd__decap_6
XFILLER_12_297 VGND VGND VPWR VPWR sky130_fd_sc_hd__decap_8
XFILLER_69_93 VPWR VGND VPWR VGND sky130_ef_sc_hd__decap_12
XFILLER_5_57 VPWR VGND VPWR VGND sky130_ef_sc_hd__decap_12
XFILLER_62_197 VGND VGND VPWR VPWR sky130_fd_sc_hd__decap_8
XFILLER_50_337 VPWR VGND VPWR VGND sky130_ef_sc_hd__decap_12
XFILLER_50_304 VGND VGND VPWR VPWR sky130_fd_sc_hd__decap_4
X_1805_ clknet_leaf_12_clock _0148_ VGND VGND VPWR VPWR scratch\[7\]\[19\] sky130_fd_sc_hd__dfxtp_1
X_1736_ clknet_leaf_1_clock _0079_ VGND VGND VPWR VPWR scratch\[2\]\[3\] sky130_fd_sc_hd__dfxtp_1
XTAP_TAPCELL_ROW_13_270 VGND VPWR sky130_fd_sc_hd__tapvpwrvgnd_1
XFILLER_58_426 VGND VGND VPWR VPWR sky130_fd_sc_hd__decap_8
XFILLER_58_404 VPWR VGND VPWR VGND sky130_ef_sc_hd__decap_12
X_1598_ scratch\[3\]\[20\] scratch\[2\]\[20\] VGND VGND VPWR VPWR _0528_ sky130_fd_sc_hd__nand2_1
X_1667_ clknet_leaf_8_clock _0010_ VGND VGND VPWR VPWR scratch\[4\]\[9\] sky130_fd_sc_hd__dfxtp_1
XTAP_TAPCELL_ROW_5_205 VGND VPWR sky130_fd_sc_hd__tapvpwrvgnd_1
XFILLER_73_429 VPWR VGND VPWR VGND sky130_ef_sc_hd__decap_12
XFILLER_30_98 VGND VGND VPWR VPWR sky130_fd_sc_hd__decap_3
XFILLER_5_249 VPWR VGND VPWR VGND sky130_ef_sc_hd__decap_12
XFILLER_5_205 VPWR VGND VPWR VGND sky130_ef_sc_hd__decap_12
XFILLER_17_301 VGND VGND VPWR VPWR sky130_fd_sc_hd__decap_8
XTAP_TAPCELL_ROW_19_318 VGND VPWR sky130_fd_sc_hd__tapvpwrvgnd_1
XFILLER_55_95 VGND VGND VPWR VPWR sky130_fd_sc_hd__fill_2
XFILLER_55_40 VPWR VGND VPWR VGND sky130_ef_sc_hd__decap_12
XFILLER_44_197 VGND VGND VPWR VPWR sky130_fd_sc_hd__decap_8
XFILLER_44_175 VGND VGND VPWR VPWR sky130_fd_sc_hd__fill_1
XFILLER_44_153 VGND VGND VPWR VPWR sky130_fd_sc_hd__fill_2
XFILLER_17_378 VPWR VGND VPWR VGND sky130_ef_sc_hd__decap_12
XFILLER_40_381 VPWR VGND VPWR VGND sky130_ef_sc_hd__decap_12
XTAP_TAPCELL_ROW_10_240 VGND VPWR sky130_fd_sc_hd__tapvpwrvgnd_1
X_1383_ net152 _0384_ _0382_ scratch\[0\]\[12\] VGND VGND VPWR VPWR _0385_ sky130_fd_sc_hd__o2bb2a_1
X_1521_ net48 _0466_ net138 VGND VGND VPWR VPWR _0467_ sky130_fd_sc_hd__mux2_1
X_1452_ net42 net157 net118 _0437_ VGND VGND VPWR VPWR _0199_ sky130_fd_sc_hd__a22o_1
XFILLER_27_109 VGND VGND VPWR VPWR sky130_fd_sc_hd__decap_3
XFILLER_23_304 VGND VGND VPWR VPWR sky130_fd_sc_hd__decap_8
XTAP_TAPCELL_ROW_61_652 VGND VPWR sky130_fd_sc_hd__tapvpwrvgnd_1
XFILLER_50_178 VPWR VGND VPWR VGND sky130_ef_sc_hd__decap_12
XFILLER_50_112 VGND VGND VPWR VPWR sky130_fd_sc_hd__decap_8
XFILLER_23_337 VGND VGND VPWR VPWR sky130_fd_sc_hd__fill_2
X_1719_ clknet_leaf_26_clock _0062_ VGND VGND VPWR VPWR scratch\[5\]\[29\] sky130_fd_sc_hd__dfxtp_1
XFILLER_58_289 VGND VGND VPWR VPWR sky130_fd_sc_hd__fill_1
XFILLER_46_429 VGND VGND VPWR VPWR sky130_fd_sc_hd__fill_2
XFILLER_73_237 VPWR VGND VPWR VGND sky130_ef_sc_hd__decap_12
XFILLER_41_145 VGND VGND VPWR VPWR sky130_fd_sc_hd__fill_1
XFILLER_26_197 VGND VGND VPWR VPWR sky130_fd_sc_hd__fill_1
XFILLER_25_87 VGND VGND VPWR VPWR sky130_fd_sc_hd__decap_4
XFILLER_25_32 VPWR VGND VPWR VGND sky130_ef_sc_hd__decap_12
XFILLER_14_348 VPWR VGND VPWR VGND sky130_ef_sc_hd__decap_12
XPHY_EDGE_ROW_16_Left_92 VGND VGND VPWR VPWR sky130_fd_sc_hd__decap_3
XFILLER_25_98 VGND VGND VPWR VPWR sky130_fd_sc_hd__decap_4
XTAP_TAPCELL_ROW_24_354 VGND VPWR sky130_fd_sc_hd__tapvpwrvgnd_1
XFILLER_49_223 VGND VGND VPWR VPWR sky130_fd_sc_hd__fill_1
XFILLER_49_201 VGND VGND VPWR VPWR sky130_fd_sc_hd__decap_4
XTAP_TAPCELL_ROW_75_766 VGND VPWR sky130_fd_sc_hd__tapvpwrvgnd_1
XFILLER_66_83 VGND VGND VPWR VPWR sky130_fd_sc_hd__fill_1
XFILLER_64_248 VGND VGND VPWR VPWR sky130_fd_sc_hd__decap_4
XFILLER_17_131 VGND VGND VPWR VPWR sky130_fd_sc_hd__decap_8
XFILLER_60_421 VPWR VGND VPWR VGND sky130_ef_sc_hd__decap_12
XFILLER_60_410 VGND VGND VPWR VPWR sky130_fd_sc_hd__decap_8
X_0952_ scratch\[4\]\[18\] net226 net218 scratch\[5\]\[18\] net234 VGND VGND VPWR
+ VPWR _0696_ sky130_fd_sc_hd__a221o_1
XFILLER_20_307 VGND VGND VPWR VPWR sky130_fd_sc_hd__fill_1
XFILLER_63_3 VPWR VGND VPWR VGND sky130_ef_sc_hd__decap_12
Xoutput104 net104 VGND VGND VPWR VPWR host_output_data[7] sky130_fd_sc_hd__clkbuf_4
X_0883_ scratch\[0\]\[7\] net223 _0637_ VGND VGND VPWR VPWR _0638_ sky130_fd_sc_hd__a21o_1
XFILLER_9_385 VGND VGND VPWR VPWR sky130_fd_sc_hd__decap_6
X_1504_ scratch\[3\]\[1\] scratch\[2\]\[1\] VGND VGND VPWR VPWR _0453_ sky130_fd_sc_hd__or2_1
X_1366_ scratch\[0\]\[7\] _0368_ _0372_ net117 VGND VGND VPWR VPWR _0373_ sky130_fd_sc_hd__o211a_1
X_1435_ net38 net157 net118 _0424_ VGND VGND VPWR VPWR _0195_ sky130_fd_sc_hd__a22o_1
XFILLER_62_19 VGND VGND VPWR VPWR sky130_fd_sc_hd__decap_8
XTAP_TAPCELL_ROW_38_468 VGND VPWR sky130_fd_sc_hd__tapvpwrvgnd_1
X_1297_ net243 net164 scratch\[7\]\[26\] VGND VGND VPWR VPWR _0327_ sky130_fd_sc_hd__or3b_1
XTAP_TAPCELL_ROW_21_335 VGND VPWR sky130_fd_sc_hd__tapvpwrvgnd_1
XFILLER_46_237 VGND VGND VPWR VPWR sky130_fd_sc_hd__fill_1
XTAP_TAPCELL_ROW_72_736 VGND VPWR sky130_fd_sc_hd__tapvpwrvgnd_1
XFILLER_52_85 VGND VGND VPWR VPWR sky130_fd_sc_hd__decap_8
XPHY_EDGE_ROW_1_Left_77 VGND VGND VPWR VPWR sky130_fd_sc_hd__decap_3
Xinput17 host_input_addr[5] VGND VGND VPWR VPWR net17 sky130_fd_sc_hd__clkbuf_1
Xinput28 host_input_data[15] VGND VGND VPWR VPWR net28 sky130_fd_sc_hd__buf_2
XFILLER_6_333 VPWR VGND VPWR VGND sky130_ef_sc_hd__decap_12
XFILLER_6_377 VPWR VGND VPWR VGND sky130_ef_sc_hd__decap_12
Xinput39 host_input_data[25] VGND VGND VPWR VPWR net39 sky130_fd_sc_hd__buf_2
XFILLER_69_329 VGND VGND VPWR VPWR sky130_fd_sc_hd__decap_6
X_1151_ net408 net122 _0798_ VGND VGND VPWR VPWR _0083_ sky130_fd_sc_hd__a21o_1
X_1220_ net246 net176 scratch\[6\]\[20\] VGND VGND VPWR VPWR _0288_ sky130_fd_sc_hd__or3b_1
XFILLER_37_204 VGND VGND VPWR VPWR sky130_fd_sc_hd__decap_8
X_1082_ net42 net192 net135 net316 VGND VGND VPWR VPWR _0029_ sky130_fd_sc_hd__a22o_1
XFILLER_60_251 VGND VGND VPWR VPWR sky130_fd_sc_hd__fill_1
X_0866_ scratch\[4\]\[4\] net222 _0623_ net253 net231 VGND VGND VPWR VPWR _0624_ sky130_fd_sc_hd__a221o_1
X_0935_ scratch\[4\]\[15\] net226 net217 scratch\[5\]\[15\] net234 VGND VGND VPWR
+ VPWR _0682_ sky130_fd_sc_hd__a221o_1
XFILLER_68_362 VGND VGND VPWR VPWR sky130_fd_sc_hd__fill_2
X_1418_ net151 _0409_ scratch\[0\]\[21\] VGND VGND VPWR VPWR _0411_ sky130_fd_sc_hd__a21oi_1
X_1349_ scratch\[0\]\[0\] scratch\[0\]\[1\] scratch\[0\]\[2\] scratch\[0\]\[3\] VGND
+ VGND VPWR VPWR _0360_ sky130_fd_sc_hd__and4_1
XFILLER_24_421 VGND VGND VPWR VPWR sky130_fd_sc_hd__decap_4
Xfanout150 net151 VGND VGND VPWR VPWR net150 sky130_fd_sc_hd__clkbuf_2
Xfanout161 net163 VGND VGND VPWR VPWR net161 sky130_fd_sc_hd__buf_2
Xfanout172 net173 VGND VGND VPWR VPWR net172 sky130_fd_sc_hd__buf_2
Xfanout183 _0789_ VGND VGND VPWR VPWR net183 sky130_fd_sc_hd__clkbuf_4
XFILLER_74_365 VPWR VGND VPWR VGND sky130_ef_sc_hd__decap_12
XFILLER_74_321 VPWR VGND VPWR VGND sky130_ef_sc_hd__decap_12
XFILLER_63_51 VGND VGND VPWR VPWR sky130_fd_sc_hd__decap_4
XFILLER_47_63 VGND VGND VPWR VPWR sky130_fd_sc_hd__fill_1
Xfanout194 net195 VGND VGND VPWR VPWR net194 sky130_fd_sc_hd__clkbuf_2
XFILLER_63_73 VPWR VGND VPWR VGND sky130_ef_sc_hd__decap_12
XTAP_TAPCELL_ROW_40_485 VGND VPWR sky130_fd_sc_hd__tapvpwrvgnd_1
XTAP_TAPCELL_ROW_32_419 VGND VPWR sky130_fd_sc_hd__tapvpwrvgnd_1
XFILLER_30_446 VGND VGND VPWR VPWR sky130_fd_sc_hd__decap_3
XFILLER_6_141 VPWR VGND VPWR VGND sky130_ef_sc_hd__decap_12
XFILLER_69_137 VPWR VGND VPWR VGND sky130_ef_sc_hd__decap_12
X_1203_ net24 net177 _0279_ VGND VGND VPWR VPWR _0108_ sky130_fd_sc_hd__a21bo_1
X_1134_ net45 net181 net123 net419 VGND VGND VPWR VPWR _0074_ sky130_fd_sc_hd__a22o_1
X_1065_ net24 net191 net134 net323 VGND VGND VPWR VPWR _0012_ sky130_fd_sc_hd__a22o_1
XFILLER_25_218 VGND VGND VPWR VPWR sky130_fd_sc_hd__decap_6
XFILLER_21_413 VGND VGND VPWR VPWR sky130_fd_sc_hd__decap_8
XFILLER_21_435 VPWR VGND VPWR VGND sky130_ef_sc_hd__decap_12
X_0918_ net251 _0664_ _0666_ _0667_ net209 VGND VGND VPWR VPWR net78 sky130_fd_sc_hd__o221a_1
X_1898_ clknet_leaf_4_clock _0240_ VGND VGND VPWR VPWR scratch\[1\]\[5\] sky130_fd_sc_hd__dfxtp_1
X_0849_ scratch\[2\]\[2\] scratch\[3\]\[2\] net264 VGND VGND VPWR VPWR _0609_ sky130_fd_sc_hd__mux2_1
XFILLER_68_29 VPWR VGND VPWR VGND sky130_ef_sc_hd__decap_12
XFILLER_75_129 VGND VGND VPWR VPWR sky130_fd_sc_hd__decap_8
XFILLER_71_335 VGND VGND VPWR VPWR sky130_fd_sc_hd__fill_1
XFILLER_56_365 VPWR VGND VPWR VGND sky130_ef_sc_hd__decap_12
XFILLER_56_321 VGND VGND VPWR VPWR sky130_fd_sc_hd__decap_4
XTAP_TAPCELL_ROW_3_188 VGND VPWR sky130_fd_sc_hd__tapvpwrvgnd_1
XTAP_TAPCELL_ROW_54_599 VGND VPWR sky130_fd_sc_hd__tapvpwrvgnd_1
XFILLER_33_43 VGND VGND VPWR VPWR sky130_fd_sc_hd__fill_1
XFILLER_12_413 VGND VGND VPWR VPWR sky130_fd_sc_hd__decap_6
XFILLER_3_111 VGND VGND VPWR VPWR sky130_fd_sc_hd__fill_1
XFILLER_47_365 VGND VGND VPWR VPWR sky130_fd_sc_hd__fill_2
XFILLER_47_321 VPWR VGND VPWR VGND sky130_ef_sc_hd__decap_12
Xhold6 scratch\[1\]\[10\] VGND VGND VPWR VPWR net282 sky130_fd_sc_hd__dlygate4sd3_1
XFILLER_74_195 VGND VGND VPWR VPWR sky130_fd_sc_hd__fill_1
XFILLER_74_83 VGND VGND VPWR VPWR sky130_fd_sc_hd__fill_1
XTAP_TAPCELL_ROW_45_522 VGND VPWR sky130_fd_sc_hd__tapvpwrvgnd_1
XPHY_EDGE_ROW_4_Left_80 VGND VGND VPWR VPWR sky130_fd_sc_hd__decap_3
X_1752_ clknet_leaf_12_clock _0095_ VGND VGND VPWR VPWR scratch\[2\]\[19\] sky130_fd_sc_hd__dfxtp_1
XFILLER_30_232 VGND VGND VPWR VPWR sky130_fd_sc_hd__decap_8
X_1683_ clknet_leaf_19_clock _0026_ VGND VGND VPWR VPWR scratch\[4\]\[25\] sky130_fd_sc_hd__dfxtp_1
X_1821_ clknet_leaf_28_clock _0163_ VGND VGND VPWR VPWR net71 sky130_fd_sc_hd__dfxtp_1
XFILLER_53_335 VGND VGND VPWR VPWR sky130_fd_sc_hd__fill_1
XFILLER_38_365 VPWR VGND VPWR VGND sky130_ef_sc_hd__decap_12
XFILLER_38_321 VPWR VGND VPWR VGND sky130_ef_sc_hd__decap_12
X_1117_ net41 net187 net130 net341 VGND VGND VPWR VPWR _0060_ sky130_fd_sc_hd__a22o_1
XTAP_TAPCELL_ROW_0_158 VGND VPWR sky130_fd_sc_hd__tapvpwrvgnd_1
XFILLER_61_390 VGND VGND VPWR VPWR sky130_fd_sc_hd__fill_2
XTAP_TAPCELL_ROW_51_569 VGND VPWR sky130_fd_sc_hd__tapvpwrvgnd_1
X_1048_ net276 net274 _0578_ _0777_ VGND VGND VPWR VPWR _0778_ sky130_fd_sc_hd__and4b_1
XPHY_EDGE_ROW_3_Right_3 VGND VGND VPWR VPWR sky130_fd_sc_hd__decap_3
XTAP_TAPCELL_ROW_16_290 VGND VPWR sky130_fd_sc_hd__tapvpwrvgnd_1
XFILLER_21_221 VGND VGND VPWR VPWR sky130_fd_sc_hd__decap_3
XTAP_TAPCELL_ROW_8_225 VGND VPWR sky130_fd_sc_hd__tapvpwrvgnd_1
XTAP_TAPCELL_ROW_59_636 VGND VPWR sky130_fd_sc_hd__tapvpwrvgnd_1
XFILLER_29_321 VGND VGND VPWR VPWR sky130_fd_sc_hd__decap_4
XFILLER_0_136 VGND VGND VPWR VPWR sky130_fd_sc_hd__decap_4
XFILLER_0_125 VGND VGND VPWR VPWR sky130_fd_sc_hd__decap_6
XFILLER_0_169 VGND VGND VPWR VPWR sky130_fd_sc_hd__decap_4
XTAP_TAPCELL_ROW_42_503 VGND VPWR sky130_fd_sc_hd__tapvpwrvgnd_1
XFILLER_29_387 VGND VGND VPWR VPWR sky130_fd_sc_hd__decap_4
XFILLER_60_85 VPWR VGND VPWR VGND sky130_ef_sc_hd__decap_12
XFILLER_60_41 VPWR VGND VPWR VGND sky130_ef_sc_hd__decap_12
XFILLER_67_405 VPWR VGND VPWR VGND sky130_ef_sc_hd__decap_12
XFILLER_5_69 VPWR VGND VPWR VGND sky130_ef_sc_hd__decap_12
XFILLER_67_449 VGND VGND VPWR VPWR sky130_fd_sc_hd__decap_4
XFILLER_62_132 VGND VGND VPWR VPWR sky130_fd_sc_hd__decap_8
XFILLER_10_6 VPWR VGND VPWR VGND sky130_ef_sc_hd__decap_12
XFILLER_62_176 VPWR VGND VPWR VGND sky130_ef_sc_hd__decap_12
XFILLER_50_349 VGND VGND VPWR VPWR sky130_fd_sc_hd__decap_6
X_1666_ clknet_leaf_5_clock _0009_ VGND VGND VPWR VPWR scratch\[4\]\[8\] sky130_fd_sc_hd__dfxtp_1
X_1804_ clknet_leaf_18_clock _0147_ VGND VGND VPWR VPWR scratch\[7\]\[18\] sky130_fd_sc_hd__dfxtp_1
X_1735_ clknet_leaf_29_clock _0078_ VGND VGND VPWR VPWR scratch\[2\]\[2\] sky130_fd_sc_hd__dfxtp_1
XTAP_TAPCELL_ROW_13_271 VGND VPWR sky130_fd_sc_hd__tapvpwrvgnd_1
X_1597_ net293 net110 _0527_ VGND VGND VPWR VPWR _0254_ sky130_fd_sc_hd__a21o_1
XFILLER_58_416 VGND VGND VPWR VPWR sky130_fd_sc_hd__decap_4
XTAP_TAPCELL_ROW_5_206 VGND VPWR sky130_fd_sc_hd__tapvpwrvgnd_1
XTAP_TAPCELL_ROW_64_672 VGND VPWR sky130_fd_sc_hd__tapvpwrvgnd_1
XFILLER_53_121 VGND VGND VPWR VPWR sky130_fd_sc_hd__fill_1
XFILLER_26_324 VPWR VGND VPWR VGND sky130_ef_sc_hd__decap_12
XFILLER_5_217 VGND VGND VPWR VPWR sky130_fd_sc_hd__decap_6
XFILLER_14_89 VGND VGND VPWR VPWR sky130_fd_sc_hd__fill_1
XFILLER_49_405 VPWR VGND VPWR VGND sky130_ef_sc_hd__decap_12
XFILLER_64_419 VGND VGND VPWR VPWR sky130_fd_sc_hd__fill_1
XFILLER_55_52 VGND VGND VPWR VPWR sky130_fd_sc_hd__decap_4
XFILLER_49_449 VGND VGND VPWR VPWR sky130_fd_sc_hd__decap_4
XTAP_TAPCELL_ROW_19_319 VGND VPWR sky130_fd_sc_hd__tapvpwrvgnd_1
XFILLER_71_51 VGND VGND VPWR VPWR sky130_fd_sc_hd__decap_4
XFILLER_55_63 VGND VGND VPWR VPWR sky130_fd_sc_hd__fill_1
XFILLER_40_360 VGND VGND VPWR VPWR sky130_fd_sc_hd__decap_4
X_1520_ net195 _0464_ _0465_ VGND VGND VPWR VPWR _0466_ sky130_fd_sc_hd__and3_1
XTAP_TAPCELL_ROW_10_241 VGND VPWR sky130_fd_sc_hd__tapvpwrvgnd_1
X_1382_ scratch\[0\]\[12\] net204 _0381_ VGND VGND VPWR VPWR _0384_ sky130_fd_sc_hd__and3_1
X_1451_ _0435_ _0436_ VGND VGND VPWR VPWR _0437_ sky130_fd_sc_hd__nor2_1
XFILLER_75_290 VGND VGND VPWR VPWR sky130_fd_sc_hd__decap_3
XFILLER_67_279 VGND VGND VPWR VPWR sky130_fd_sc_hd__fill_1
XFILLER_63_441 VGND VGND VPWR VPWR sky130_fd_sc_hd__decap_6
XTAP_TAPCELL_ROW_61_653 VGND VPWR sky130_fd_sc_hd__tapvpwrvgnd_1
XFILLER_31_393 VGND VGND VPWR VPWR sky130_fd_sc_hd__decap_6
X_1649_ scratch\[3\]\[30\] scratch\[2\]\[30\] VGND VGND VPWR VPWR _0569_ sky130_fd_sc_hd__or2_1
XFILLER_2_209 VPWR VGND VPWR VGND sky130_ef_sc_hd__decap_12
X_1718_ clknet_leaf_23_clock _0061_ VGND VGND VPWR VPWR scratch\[5\]\[28\] sky130_fd_sc_hd__dfxtp_1
XFILLER_73_249 VPWR VGND VPWR VGND sky130_ef_sc_hd__decap_12
XFILLER_73_205 VPWR VGND VPWR VGND sky130_ef_sc_hd__decap_12
XFILLER_58_257 VGND VGND VPWR VPWR sky130_fd_sc_hd__fill_1
XFILLER_46_419 VGND VGND VPWR VPWR sky130_fd_sc_hd__fill_1
XFILLER_25_66 VGND VGND VPWR VPWR sky130_fd_sc_hd__decap_4
XFILLER_25_55 VGND VGND VPWR VPWR sky130_fd_sc_hd__fill_1
XFILLER_25_44 VGND VGND VPWR VPWR sky130_fd_sc_hd__decap_4
XTAP_TAPCELL_ROW_24_355 VGND VPWR sky130_fd_sc_hd__tapvpwrvgnd_1
XFILLER_2_15 VPWR VGND VPWR VGND sky130_ef_sc_hd__decap_12
XTAP_TAPCELL_ROW_75_767 VGND VPWR sky130_fd_sc_hd__tapvpwrvgnd_1
XFILLER_32_102 VGND VGND VPWR VPWR sky130_fd_sc_hd__fill_1
XFILLER_17_165 VGND VGND VPWR VPWR sky130_fd_sc_hd__decap_3
XFILLER_17_187 VPWR VGND VPWR VGND sky130_ef_sc_hd__decap_12
XFILLER_60_433 VPWR VGND VPWR VGND sky130_ef_sc_hd__decap_12
X_0882_ scratch\[1\]\[7\] net214 _0636_ net255 net248 VGND VGND VPWR VPWR _0637_ sky130_fd_sc_hd__a221o_1
X_0951_ scratch\[6\]\[18\] scratch\[7\]\[18\] net269 VGND VGND VPWR VPWR _0695_ sky130_fd_sc_hd__mux2_1
XFILLER_13_393 VPWR VGND VPWR VGND sky130_ef_sc_hd__decap_12
Xoutput105 net105 VGND VGND VPWR VPWR host_output_data[8] sky130_fd_sc_hd__buf_2
XFILLER_56_3 VGND VGND VPWR VPWR sky130_fd_sc_hd__decap_8
X_1503_ scratch\[3\]\[1\] scratch\[2\]\[1\] VGND VGND VPWR VPWR _0452_ sky130_fd_sc_hd__nand2_1
XFILLER_55_205 VPWR VGND VPWR VGND sky130_ef_sc_hd__decap_12
X_1365_ net147 net204 VGND VGND VPWR VPWR _0372_ sky130_fd_sc_hd__nand2_1
XFILLER_28_419 VGND VGND VPWR VPWR sky130_fd_sc_hd__fill_1
X_1434_ _0579_ _0420_ _0423_ VGND VGND VPWR VPWR _0424_ sky130_fd_sc_hd__a21oi_1
X_1296_ net39 net164 _0326_ VGND VGND VPWR VPWR _0154_ sky130_fd_sc_hd__a21bo_1
XTAP_TAPCELL_ROW_38_469 VGND VPWR sky130_fd_sc_hd__tapvpwrvgnd_1
XFILLER_11_79 VGND VGND VPWR VPWR sky130_fd_sc_hd__fill_1
XTAP_TAPCELL_ROW_72_737 VGND VPWR sky130_fd_sc_hd__tapvpwrvgnd_1
XFILLER_42_411 VGND VGND VPWR VPWR sky130_fd_sc_hd__decap_8
XFILLER_36_10 VGND VGND VPWR VPWR sky130_fd_sc_hd__fill_1
XFILLER_14_102 VPWR VGND VPWR VGND sky130_ef_sc_hd__decap_12
Xinput18 host_input_addr[6] VGND VGND VPWR VPWR net18 sky130_fd_sc_hd__buf_1
XFILLER_6_301 VGND VGND VPWR VPWR sky130_fd_sc_hd__decap_6
Xinput29 host_input_data[16] VGND VGND VPWR VPWR net29 sky130_fd_sc_hd__buf_2
XFILLER_6_345 VPWR VGND VPWR VGND sky130_ef_sc_hd__decap_12
XFILLER_6_389 VPWR VGND VPWR VGND sky130_ef_sc_hd__decap_12
X_1150_ net19 net196 net180 net51 VGND VGND VPWR VPWR _0798_ sky130_fd_sc_hd__a22o_1
XFILLER_52_219 VPWR VGND VPWR VGND sky130_ef_sc_hd__decap_12
X_1081_ net41 net192 net135 net346 VGND VGND VPWR VPWR _0028_ sky130_fd_sc_hd__a22o_1
X_0865_ scratch\[6\]\[4\] scratch\[7\]\[4\] net266 VGND VGND VPWR VPWR _0623_ sky130_fd_sc_hd__mux2_1
X_0934_ scratch\[6\]\[15\] scratch\[7\]\[15\] net268 VGND VGND VPWR VPWR _0681_ sky130_fd_sc_hd__mux2_1
X_1417_ net34 net156 net119 _0410_ VGND VGND VPWR VPWR _0191_ sky130_fd_sc_hd__a22o_1
X_1279_ net245 net166 scratch\[7\]\[17\] VGND VGND VPWR VPWR _0318_ sky130_fd_sc_hd__or3b_1
X_1348_ _0585_ net149 VGND VGND VPWR VPWR _0359_ sky130_fd_sc_hd__nand2_1
XFILLER_11_105 VGND VGND VPWR VPWR sky130_fd_sc_hd__decap_6
XFILLER_11_149 VGND VGND VPWR VPWR sky130_fd_sc_hd__fill_1
XFILLER_3_337 VPWR VGND VPWR VGND sky130_ef_sc_hd__decap_12
XFILLER_74_333 VPWR VGND VPWR VGND sky130_ef_sc_hd__decap_12
Xfanout162 net163 VGND VGND VPWR VPWR net162 sky130_fd_sc_hd__clkbuf_2
Xfanout151 net152 VGND VGND VPWR VPWR net151 sky130_fd_sc_hd__dlymetal6s2s_1
Xfanout173 _0267_ VGND VGND VPWR VPWR net173 sky130_fd_sc_hd__clkbuf_2
Xfanout140 net141 VGND VGND VPWR VPWR net140 sky130_fd_sc_hd__clkbuf_4
Xfanout195 net197 VGND VGND VPWR VPWR net195 sky130_fd_sc_hd__buf_2
Xfanout184 net185 VGND VGND VPWR VPWR net184 sky130_fd_sc_hd__buf_2
XFILLER_19_216 VGND VGND VPWR VPWR sky130_fd_sc_hd__decap_8
XFILLER_74_377 VPWR VGND VPWR VGND sky130_ef_sc_hd__decap_12
XTAP_TAPCELL_ROW_40_486 VGND VPWR sky130_fd_sc_hd__tapvpwrvgnd_1
XFILLER_6_153 VPWR VGND VPWR VGND sky130_ef_sc_hd__decap_12
XFILLER_69_149 VPWR VGND VPWR VGND sky130_ef_sc_hd__decap_12
XFILLER_69_105 VGND VGND VPWR VPWR sky130_fd_sc_hd__decap_6
XFILLER_6_197 VPWR VGND VPWR VGND sky130_ef_sc_hd__decap_12
X_1202_ net245 net177 scratch\[6\]\[11\] VGND VGND VPWR VPWR _0279_ sky130_fd_sc_hd__or3b_1
X_1064_ net23 net189 net132 net372 VGND VGND VPWR VPWR _0011_ sky130_fd_sc_hd__a22o_1
X_1133_ net43 net181 net123 net418 VGND VGND VPWR VPWR _0073_ sky130_fd_sc_hd__a22o_1
XFILLER_33_241 VGND VGND VPWR VPWR sky130_fd_sc_hd__fill_1
XFILLER_21_447 VGND VGND VPWR VPWR sky130_fd_sc_hd__fill_1
X_0917_ scratch\[4\]\[12\] net228 net219 scratch\[5\]\[12\] net233 VGND VGND VPWR
+ VPWR _0667_ sky130_fd_sc_hd__a221o_1
X_1897_ clknet_leaf_3_clock _0239_ VGND VGND VPWR VPWR scratch\[1\]\[4\] sky130_fd_sc_hd__dfxtp_1
X_0848_ net70 _0601_ _0602_ net211 _0608_ VGND VGND VPWR VPWR net86 sky130_fd_sc_hd__a221o_1
XFILLER_56_333 VGND VGND VPWR VPWR sky130_fd_sc_hd__fill_1
XTAP_TAPCELL_ROW_3_189 VGND VPWR sky130_fd_sc_hd__tapvpwrvgnd_1
XFILLER_17_89 VGND VGND VPWR VPWR sky130_fd_sc_hd__fill_1
XFILLER_3_167 VGND VGND VPWR VPWR sky130_fd_sc_hd__fill_1
XFILLER_74_141 VPWR VGND VPWR VGND sky130_ef_sc_hd__decap_12
XFILLER_58_85 VGND VGND VPWR VPWR sky130_fd_sc_hd__decap_4
XFILLER_47_333 VGND VGND VPWR VPWR sky130_fd_sc_hd__decap_3
Xhold7 scratch\[1\]\[23\] VGND VGND VPWR VPWR net283 sky130_fd_sc_hd__dlygate4sd3_1
XTAP_TAPCELL_ROW_45_523 VGND VPWR sky130_fd_sc_hd__tapvpwrvgnd_1
XFILLER_15_285 VGND VGND VPWR VPWR sky130_fd_sc_hd__fill_1
X_1820_ clknet_leaf_28_clock _0162_ VGND VGND VPWR VPWR net70 sky130_fd_sc_hd__dfxtp_1
X_1751_ clknet_leaf_16_clock _0094_ VGND VGND VPWR VPWR scratch\[2\]\[18\] sky130_fd_sc_hd__dfxtp_1
X_1682_ clknet_leaf_21_clock _0025_ VGND VGND VPWR VPWR scratch\[4\]\[24\] sky130_fd_sc_hd__dfxtp_1
XFILLER_38_377 VPWR VGND VPWR VGND sky130_ef_sc_hd__decap_12
XFILLER_38_344 VPWR VGND VPWR VGND sky130_ef_sc_hd__decap_12
XFILLER_38_333 VGND VGND VPWR VPWR sky130_fd_sc_hd__decap_4
X_1047_ _0767_ _0769_ _0772_ _0776_ VGND VGND VPWR VPWR _0777_ sky130_fd_sc_hd__and4_2
X_1116_ net40 net187 net130 net343 VGND VGND VPWR VPWR _0059_ sky130_fd_sc_hd__a22o_1
XFILLER_0_81 VGND VGND VPWR VPWR sky130_fd_sc_hd__decap_3
XTAP_TAPCELL_ROW_0_159 VGND VPWR sky130_fd_sc_hd__tapvpwrvgnd_1
XTAP_TAPCELL_ROW_16_291 VGND VPWR sky130_fd_sc_hd__tapvpwrvgnd_1
XTAP_TAPCELL_ROW_8_226 VGND VPWR sky130_fd_sc_hd__tapvpwrvgnd_1
XTAP_TAPCELL_ROW_59_637 VGND VPWR sky130_fd_sc_hd__tapvpwrvgnd_1
XFILLER_56_141 VGND VGND VPWR VPWR sky130_fd_sc_hd__fill_1
XFILLER_48_119 VGND VGND VPWR VPWR sky130_fd_sc_hd__fill_2
XFILLER_28_33 VGND VGND VPWR VPWR sky130_fd_sc_hd__fill_1
XFILLER_71_111 VGND VGND VPWR VPWR sky130_fd_sc_hd__fill_1
XFILLER_60_97 VPWR VGND VPWR VGND sky130_ef_sc_hd__decap_12
XFILLER_60_53 VPWR VGND VPWR VGND sky130_ef_sc_hd__decap_12
XFILLER_4_421 VPWR VGND VPWR VGND sky130_ef_sc_hd__decap_12
XFILLER_8_248 VGND VGND VPWR VPWR sky130_fd_sc_hd__decap_4
XFILLER_69_51 VGND VGND VPWR VPWR sky130_fd_sc_hd__decap_4
XFILLER_67_417 VPWR VGND VPWR VGND sky130_ef_sc_hd__decap_12
XFILLER_47_185 VPWR VGND VPWR VGND sky130_ef_sc_hd__decap_12
XPHY_EDGE_ROW_13_Right_13 VGND VGND VPWR VPWR sky130_fd_sc_hd__decap_3
X_1803_ clknet_leaf_11_clock _0146_ VGND VGND VPWR VPWR scratch\[7\]\[17\] sky130_fd_sc_hd__dfxtp_1
XFILLER_62_188 VGND VGND VPWR VPWR sky130_fd_sc_hd__decap_8
XFILLER_43_391 VGND VGND VPWR VPWR sky130_fd_sc_hd__fill_1
XPHY_EDGE_ROW_22_Right_22 VGND VGND VPWR VPWR sky130_fd_sc_hd__decap_3
X_1596_ net32 _0526_ net140 VGND VGND VPWR VPWR _0527_ sky130_fd_sc_hd__mux2_1
X_1665_ clknet_leaf_5_clock _0008_ VGND VGND VPWR VPWR scratch\[4\]\[7\] sky130_fd_sc_hd__dfxtp_1
X_1734_ clknet_leaf_29_clock _0077_ VGND VGND VPWR VPWR scratch\[2\]\[1\] sky130_fd_sc_hd__dfxtp_1
XFILLER_7_281 VPWR VGND VPWR VGND sky130_ef_sc_hd__decap_12
XFILLER_38_141 VGND VGND VPWR VPWR sky130_fd_sc_hd__decap_8
XPHY_EDGE_ROW_31_Right_31 VGND VGND VPWR VPWR sky130_fd_sc_hd__decap_3
XTAP_TAPCELL_ROW_5_207 VGND VPWR sky130_fd_sc_hd__tapvpwrvgnd_1
XTAP_TAPCELL_ROW_64_673 VGND VPWR sky130_fd_sc_hd__tapvpwrvgnd_1
XFILLER_53_166 VGND VGND VPWR VPWR sky130_fd_sc_hd__fill_2
XFILLER_41_328 VGND VGND VPWR VPWR sky130_fd_sc_hd__decap_8
XFILLER_41_306 VGND VGND VPWR VPWR sky130_fd_sc_hd__fill_1
XFILLER_38_174 VGND VGND VPWR VPWR sky130_fd_sc_hd__fill_2
XFILLER_34_380 VGND VGND VPWR VPWR sky130_fd_sc_hd__fill_1
XFILLER_26_336 VGND VGND VPWR VPWR sky130_fd_sc_hd__decap_8
XPHY_EDGE_ROW_40_Right_40 VGND VGND VPWR VPWR sky130_fd_sc_hd__decap_3
XFILLER_30_23 VGND VGND VPWR VPWR sky130_fd_sc_hd__decap_4
XFILLER_49_417 VGND VGND VPWR VPWR sky130_fd_sc_hd__fill_1
XFILLER_55_75 VGND VGND VPWR VPWR sky130_fd_sc_hd__decap_4
XPHY_EDGE_ROW_24_Left_100 VGND VGND VPWR VPWR sky130_fd_sc_hd__decap_3
XFILLER_32_306 VGND VGND VPWR VPWR sky130_fd_sc_hd__fill_2
XFILLER_25_391 VGND VGND VPWR VPWR sky130_fd_sc_hd__fill_1
X_1450_ scratch\[0\]\[28\] net153 _0433_ VGND VGND VPWR VPWR _0436_ sky130_fd_sc_hd__and3_1
XFILLER_4_251 VGND VGND VPWR VPWR sky130_fd_sc_hd__fill_1
XTAP_TAPCELL_ROW_10_242 VGND VPWR sky130_fd_sc_hd__tapvpwrvgnd_1
XFILLER_67_225 VGND VGND VPWR VPWR sky130_fd_sc_hd__decap_6
X_1381_ net24 net156 _0383_ VGND VGND VPWR VPWR _0182_ sky130_fd_sc_hd__a21o_1
XTAP_TAPCELL_ROW_61_654 VGND VPWR sky130_fd_sc_hd__tapvpwrvgnd_1
X_1579_ scratch\[3\]\[16\] scratch\[2\]\[16\] VGND VGND VPWR VPWR _0513_ sky130_fd_sc_hd__or2_1
X_1648_ scratch\[3\]\[30\] scratch\[2\]\[30\] VGND VGND VPWR VPWR _0568_ sky130_fd_sc_hd__nand2_1
X_1717_ clknet_leaf_19_clock _0060_ VGND VGND VPWR VPWR scratch\[5\]\[27\] sky130_fd_sc_hd__dfxtp_1
XFILLER_73_217 VGND VGND VPWR VPWR sky130_fd_sc_hd__decap_6
XTAP_TAPCELL_ROW_24_356 VGND VPWR sky130_fd_sc_hd__tapvpwrvgnd_1
XFILLER_22_383 VGND VGND VPWR VPWR sky130_fd_sc_hd__decap_8
XFILLER_66_41 VPWR VGND VPWR VGND sky130_ef_sc_hd__decap_12
XFILLER_49_225 VGND VGND VPWR VPWR sky130_fd_sc_hd__decap_8
XFILLER_37_409 VGND VGND VPWR VPWR sky130_fd_sc_hd__fill_1
XFILLER_2_27 VGND VGND VPWR VPWR sky130_fd_sc_hd__fill_1
XTAP_TAPCELL_ROW_75_768 VGND VPWR sky130_fd_sc_hd__tapvpwrvgnd_1
XFILLER_66_85 VPWR VGND VPWR VGND sky130_ef_sc_hd__decap_12
XFILLER_60_445 VGND VGND VPWR VPWR sky130_fd_sc_hd__decap_4
XFILLER_17_177 VGND VGND VPWR VPWR sky130_fd_sc_hd__fill_2
XFILLER_17_199 VGND VGND VPWR VPWR sky130_fd_sc_hd__fill_2
X_0881_ scratch\[2\]\[7\] scratch\[3\]\[7\] net265 VGND VGND VPWR VPWR _0636_ sky130_fd_sc_hd__mux2_1
XFILLER_40_191 VGND VGND VPWR VPWR sky130_fd_sc_hd__decap_4
X_0950_ scratch\[1\]\[18\] net218 _0693_ VGND VGND VPWR VPWR _0694_ sky130_fd_sc_hd__a21o_1
XFILLER_9_310 VGND VGND VPWR VPWR sky130_fd_sc_hd__decap_8
XFILLER_13_361 VPWR VGND VPWR VGND sky130_ef_sc_hd__decap_12
XFILLER_20_309 VPWR VGND VPWR VGND sky130_ef_sc_hd__decap_12
Xoutput106 net106 VGND VGND VPWR VPWR host_output_data[9] sky130_fd_sc_hd__buf_2
XFILLER_49_3 VPWR VGND VPWR VGND sky130_ef_sc_hd__decap_12
X_1433_ scratch\[0\]\[24\] net153 _0421_ VGND VGND VPWR VPWR _0423_ sky130_fd_sc_hd__and3_1
X_1502_ net289 net108 _0451_ VGND VGND VPWR VPWR _0235_ sky130_fd_sc_hd__a21o_1
XFILLER_70_209 VPWR VGND VPWR VGND sky130_ef_sc_hd__decap_12
XFILLER_55_217 VGND VGND VPWR VPWR sky130_fd_sc_hd__decap_6
X_1364_ _0360_ _0370_ VGND VGND VPWR VPWR _0371_ sky130_fd_sc_hd__and2_1
X_1295_ net243 net164 scratch\[7\]\[25\] VGND VGND VPWR VPWR _0326_ sky130_fd_sc_hd__or3b_1
XFILLER_63_261 VGND VGND VPWR VPWR sky130_fd_sc_hd__fill_2
XFILLER_23_169 VGND VGND VPWR VPWR sky130_fd_sc_hd__decap_8
XTAP_TAPCELL_ROW_72_738 VGND VPWR sky130_fd_sc_hd__tapvpwrvgnd_1
XFILLER_36_66 VPWR VGND VPWR VGND sky130_ef_sc_hd__decap_12
XFILLER_14_114 VGND VGND VPWR VPWR sky130_fd_sc_hd__decap_3
Xinput19 host_input_addr[7] VGND VGND VPWR VPWR net19 sky130_fd_sc_hd__clkbuf_1
XFILLER_22_191 VGND VGND VPWR VPWR sky130_fd_sc_hd__decap_4
XFILLER_6_357 VGND VGND VPWR VPWR sky130_fd_sc_hd__decap_6
X_1080_ net40 net192 net135 net360 VGND VGND VPWR VPWR _0027_ sky130_fd_sc_hd__a22o_1
XFILLER_60_253 VGND VGND VPWR VPWR sky130_fd_sc_hd__decap_8
X_0864_ net255 _0620_ _0621_ VGND VGND VPWR VPWR _0622_ sky130_fd_sc_hd__a21o_1
X_0933_ scratch\[1\]\[15\] net217 _0679_ VGND VGND VPWR VPWR _0680_ sky130_fd_sc_hd__a21o_1
X_1416_ net150 _0409_ _0408_ VGND VGND VPWR VPWR _0410_ sky130_fd_sc_hd__a21oi_1
X_1347_ net198 _0348_ VGND VGND VPWR VPWR _0358_ sky130_fd_sc_hd__nor2_1
XFILLER_3_81 VPWR VGND VPWR VGND sky130_ef_sc_hd__decap_12
X_1278_ net29 net166 _0317_ VGND VGND VPWR VPWR _0145_ sky130_fd_sc_hd__a21bo_1
XFILLER_24_401 VGND VGND VPWR VPWR sky130_fd_sc_hd__decap_8
XFILLER_51_242 VPWR VGND VPWR VGND sky130_ef_sc_hd__decap_12
XFILLER_3_349 VPWR VGND VPWR VGND sky130_ef_sc_hd__decap_12
XFILLER_3_305 VPWR VGND VPWR VGND sky130_ef_sc_hd__decap_12
XFILLER_74_345 VPWR VGND VPWR VGND sky130_ef_sc_hd__decap_12
XFILLER_74_301 VGND VGND VPWR VPWR sky130_fd_sc_hd__decap_6
XFILLER_59_375 VGND VGND VPWR VPWR sky130_fd_sc_hd__fill_1
Xfanout130 net131 VGND VGND VPWR VPWR net130 sky130_fd_sc_hd__buf_2
Xfanout196 net197 VGND VGND VPWR VPWR net196 sky130_fd_sc_hd__buf_2
XFILLER_47_43 VPWR VGND VPWR VGND sky130_ef_sc_hd__decap_12
Xfanout163 _0300_ VGND VGND VPWR VPWR net163 sky130_fd_sc_hd__clkbuf_2
Xfanout152 net153 VGND VGND VPWR VPWR net152 sky130_fd_sc_hd__dlymetal6s2s_1
Xfanout141 _0446_ VGND VGND VPWR VPWR net141 sky130_fd_sc_hd__buf_2
Xfanout174 net178 VGND VGND VPWR VPWR net174 sky130_fd_sc_hd__clkbuf_2
Xfanout185 net188 VGND VGND VPWR VPWR net185 sky130_fd_sc_hd__clkbuf_4
XFILLER_74_389 VPWR VGND VPWR VGND sky130_ef_sc_hd__decap_12
XPHY_EDGE_ROW_69_Right_69 VGND VGND VPWR VPWR sky130_fd_sc_hd__decap_3
XFILLER_27_261 VGND VGND VPWR VPWR sky130_fd_sc_hd__decap_4
XFILLER_27_272 VGND VGND VPWR VPWR sky130_fd_sc_hd__decap_8
XTAP_TAPCELL_ROW_40_487 VGND VPWR sky130_fd_sc_hd__tapvpwrvgnd_1
XFILLER_6_121 VPWR VGND VPWR VGND sky130_ef_sc_hd__decap_12
XFILLER_6_165 VPWR VGND VPWR VGND sky130_ef_sc_hd__decap_12
XFILLER_8_26 VGND VGND VPWR VPWR sky130_fd_sc_hd__fill_2
X_1201_ net23 net172 _0278_ VGND VGND VPWR VPWR _0107_ sky130_fd_sc_hd__a21bo_1
XFILLER_40_7 VPWR VGND VPWR VGND sky130_ef_sc_hd__decap_12
X_1063_ net53 net189 net132 net368 VGND VGND VPWR VPWR _0010_ sky130_fd_sc_hd__a22o_1
X_1132_ net42 net181 net123 net400 VGND VGND VPWR VPWR _0072_ sky130_fd_sc_hd__a22o_1
XFILLER_18_250 VGND VGND VPWR VPWR sky130_fd_sc_hd__fill_2
X_0916_ net261 _0665_ VGND VGND VPWR VPWR _0666_ sky130_fd_sc_hd__and2_1
XFILLER_33_231 VGND VGND VPWR VPWR sky130_fd_sc_hd__decap_4
XTAP_TAPCELL_ROW_31_410 VGND VPWR sky130_fd_sc_hd__tapvpwrvgnd_1
X_1896_ clknet_leaf_1_clock _0238_ VGND VGND VPWR VPWR scratch\[1\]\[3\] sky130_fd_sc_hd__dfxtp_1
X_0847_ _0605_ _0606_ _0607_ net249 net206 VGND VGND VPWR VPWR _0608_ sky130_fd_sc_hd__o221a_1
XFILLER_75_109 VGND VGND VPWR VPWR sky130_fd_sc_hd__decap_3
XFILLER_68_172 VGND VGND VPWR VPWR sky130_fd_sc_hd__decap_4
XFILLER_71_337 VPWR VGND VPWR VGND sky130_ef_sc_hd__decap_12
XFILLER_33_23 VPWR VGND VPWR VGND sky130_ef_sc_hd__decap_12
XFILLER_24_253 VPWR VGND VPWR VGND sky130_ef_sc_hd__decap_12
XFILLER_17_57 VGND VGND VPWR VPWR sky130_fd_sc_hd__fill_1
XFILLER_8_419 VGND VGND VPWR VPWR sky130_fd_sc_hd__fill_1
XFILLER_66_109 VPWR VGND VPWR VGND sky130_ef_sc_hd__decap_12
XFILLER_3_113 VPWR VGND VPWR VGND sky130_ef_sc_hd__decap_12
XFILLER_74_197 VPWR VGND VPWR VGND sky130_ef_sc_hd__decap_12
XFILLER_74_153 VPWR VGND VPWR VGND sky130_ef_sc_hd__decap_12
XFILLER_74_85 VPWR VGND VPWR VGND sky130_ef_sc_hd__decap_12
XFILLER_74_41 VPWR VGND VPWR VGND sky130_ef_sc_hd__decap_12
Xhold8 scratch\[1\]\[14\] VGND VGND VPWR VPWR net284 sky130_fd_sc_hd__dlygate4sd3_1
XTAP_TAPCELL_ROW_45_524 VGND VPWR sky130_fd_sc_hd__tapvpwrvgnd_1
X_1750_ clknet_leaf_11_clock _0093_ VGND VGND VPWR VPWR scratch\[2\]\[17\] sky130_fd_sc_hd__dfxtp_1
XTAP_TAPCELL_ROW_53_590 VGND VPWR sky130_fd_sc_hd__tapvpwrvgnd_1
XFILLER_15_253 VGND VGND VPWR VPWR sky130_fd_sc_hd__decap_8
XFILLER_15_297 VPWR VGND VPWR VGND sky130_ef_sc_hd__decap_12
X_1681_ clknet_leaf_14_clock _0024_ VGND VGND VPWR VPWR scratch\[4\]\[23\] sky130_fd_sc_hd__dfxtp_1
XFILLER_7_441 VGND VGND VPWR VPWR sky130_fd_sc_hd__decap_6
XFILLER_65_186 VGND VGND VPWR VPWR sky130_fd_sc_hd__decap_6
XFILLER_61_370 VPWR VGND VPWR VGND sky130_ef_sc_hd__decap_12
XFILLER_53_337 VPWR VGND VPWR VGND sky130_ef_sc_hd__decap_12
XFILLER_38_389 VGND VGND VPWR VPWR sky130_fd_sc_hd__decap_3
XFILLER_38_356 VGND VGND VPWR VPWR sky130_fd_sc_hd__decap_8
X_1046_ _0773_ _0774_ _0775_ VGND VGND VPWR VPWR _0776_ sky130_fd_sc_hd__nor3_1
X_1115_ net39 net187 net130 net344 VGND VGND VPWR VPWR _0058_ sky130_fd_sc_hd__a22o_1
XFILLER_21_201 VPWR VGND VPWR VGND sky130_ef_sc_hd__decap_12
X_1879_ clknet_leaf_17_clock _0221_ VGND VGND VPWR VPWR scratch\[3\]\[18\] sky130_fd_sc_hd__dfxtp_1
XTAP_TAPCELL_ROW_16_292 VGND VPWR sky130_fd_sc_hd__tapvpwrvgnd_1
XTAP_TAPCELL_ROW_8_227 VGND VPWR sky130_fd_sc_hd__tapvpwrvgnd_1
XTAP_TAPCELL_ROW_59_638 VGND VPWR sky130_fd_sc_hd__tapvpwrvgnd_1
XFILLER_56_197 VGND VGND VPWR VPWR sky130_fd_sc_hd__decap_4
XFILLER_71_167 VGND VGND VPWR VPWR sky130_fd_sc_hd__fill_1
XFILLER_60_21 VGND VGND VPWR VPWR sky130_fd_sc_hd__decap_6
XTAP_TAPCELL_ROW_50_560 VGND VPWR sky130_fd_sc_hd__tapvpwrvgnd_1
XFILLER_44_11 VGND VGND VPWR VPWR sky130_fd_sc_hd__decap_3
XFILLER_60_65 VPWR VGND VPWR VGND sky130_ef_sc_hd__decap_12
XFILLER_4_433 VPWR VGND VPWR VGND sky130_ef_sc_hd__decap_12
XFILLER_67_429 VPWR VGND VPWR VGND sky130_ef_sc_hd__decap_12
XFILLER_39_109 VGND VGND VPWR VPWR sky130_fd_sc_hd__decap_3
XFILLER_47_197 VPWR VGND VPWR VGND sky130_ef_sc_hd__decap_12
XFILLER_35_337 VGND VGND VPWR VPWR sky130_fd_sc_hd__decap_6
X_1802_ clknet_leaf_9_clock _0145_ VGND VGND VPWR VPWR scratch\[7\]\[16\] sky130_fd_sc_hd__dfxtp_1
X_1733_ clknet_leaf_25_clock _0076_ VGND VGND VPWR VPWR scratch\[2\]\[0\] sky130_fd_sc_hd__dfxtp_1
X_1595_ net201 _0524_ _0525_ VGND VGND VPWR VPWR _0526_ sky130_fd_sc_hd__and3_1
X_1664_ clknet_leaf_3_clock _0007_ VGND VGND VPWR VPWR scratch\[4\]\[6\] sky130_fd_sc_hd__dfxtp_1
XFILLER_7_293 VPWR VGND VPWR VGND sky130_ef_sc_hd__decap_12
XTAP_TAPCELL_ROW_56_608 VGND VPWR sky130_fd_sc_hd__tapvpwrvgnd_1
XFILLER_38_197 VPWR VGND VPWR VGND sky130_ef_sc_hd__decap_12
XTAP_TAPCELL_ROW_64_674 VGND VPWR sky130_fd_sc_hd__tapvpwrvgnd_1
X_1029_ scratch\[2\]\[31\] scratch\[3\]\[31\] net263 VGND VGND VPWR VPWR _0760_ sky130_fd_sc_hd__mux2_1
XFILLER_1_447 VGND VGND VPWR VPWR sky130_fd_sc_hd__fill_1
XFILLER_72_421 VPWR VGND VPWR VGND sky130_ef_sc_hd__decap_12
XFILLER_32_329 VPWR VGND VPWR VGND sky130_ef_sc_hd__decap_12
XTAP_TAPCELL_ROW_27_376 VGND VPWR sky130_fd_sc_hd__tapvpwrvgnd_1
XTAP_TAPCELL_ROW_10_243 VGND VPWR sky130_fd_sc_hd__tapvpwrvgnd_1
X_1380_ _0358_ _0380_ _0382_ VGND VGND VPWR VPWR _0383_ sky130_fd_sc_hd__nor3_1
XFILLER_20_90 VPWR VGND VPWR VGND sky130_ef_sc_hd__decap_12
XFILLER_75_281 VGND VGND VPWR VPWR sky130_fd_sc_hd__decap_4
XFILLER_75_270 VGND VGND VPWR VPWR sky130_fd_sc_hd__fill_2
XTAP_TAPCELL_ROW_61_655 VGND VPWR sky130_fd_sc_hd__tapvpwrvgnd_1
XFILLER_50_126 VPWR VGND VPWR VGND sky130_ef_sc_hd__decap_12
XFILLER_23_329 VGND VGND VPWR VPWR sky130_fd_sc_hd__decap_6
XTAP_TAPCELL_ROW_18_310 VGND VPWR sky130_fd_sc_hd__tapvpwrvgnd_1
X_1716_ clknet_leaf_19_clock _0059_ VGND VGND VPWR VPWR scratch\[5\]\[26\] sky130_fd_sc_hd__dfxtp_1
XFILLER_58_215 VPWR VGND VPWR VGND sky130_ef_sc_hd__decap_12
X_1578_ scratch\[3\]\[16\] scratch\[2\]\[16\] VGND VGND VPWR VPWR _0512_ sky130_fd_sc_hd__nand2_1
X_1647_ net300 net109 _0567_ VGND VGND VPWR VPWR _0264_ sky130_fd_sc_hd__a21o_1
XFILLER_54_421 VGND VGND VPWR VPWR sky130_fd_sc_hd__decap_6
XFILLER_26_112 VPWR VGND VPWR VGND sky130_ef_sc_hd__decap_12
XFILLER_14_307 VGND VGND VPWR VPWR sky130_fd_sc_hd__fill_1
XTAP_TAPCELL_ROW_24_357 VGND VPWR sky130_fd_sc_hd__tapvpwrvgnd_1
XFILLER_9_3 VGND VGND VPWR VPWR sky130_fd_sc_hd__decap_4
XFILLER_66_97 VPWR VGND VPWR VGND sky130_ef_sc_hd__decap_12
XFILLER_66_53 VPWR VGND VPWR VGND sky130_ef_sc_hd__decap_12
XFILLER_57_281 VPWR VGND VPWR VGND sky130_ef_sc_hd__decap_12
XFILLER_49_259 VGND VGND VPWR VPWR sky130_fd_sc_hd__decap_4
XFILLER_49_237 VGND VGND VPWR VPWR sky130_fd_sc_hd__decap_6
XTAP_TAPCELL_ROW_75_769 VGND VPWR sky130_fd_sc_hd__tapvpwrvgnd_1
XFILLER_72_251 VGND VGND VPWR VPWR sky130_fd_sc_hd__fill_1
XFILLER_45_443 VGND VGND VPWR VPWR sky130_fd_sc_hd__decap_4
XFILLER_32_159 VPWR VGND VPWR VGND sky130_ef_sc_hd__decap_12
X_0880_ net207 _0632_ _0635_ VGND VGND VPWR VPWR net103 sky130_fd_sc_hd__and3_1
XFILLER_13_373 VPWR VGND VPWR VGND sky130_ef_sc_hd__decap_12
X_1363_ scratch\[0\]\[4\] scratch\[0\]\[5\] scratch\[0\]\[6\] scratch\[0\]\[7\] VGND
+ VGND VPWR VPWR _0370_ sky130_fd_sc_hd__and4_1
X_1432_ net37 net157 _0422_ VGND VGND VPWR VPWR _0194_ sky130_fd_sc_hd__a21bo_1
X_1501_ net22 _0450_ net137 VGND VGND VPWR VPWR _0451_ sky130_fd_sc_hd__mux2_1
XPHY_EDGE_ROW_43_Left_119 VGND VGND VPWR VPWR sky130_fd_sc_hd__decap_3
XFILLER_36_421 VPWR VGND VPWR VGND sky130_ef_sc_hd__decap_12
X_1294_ net38 net165 _0325_ VGND VGND VPWR VPWR _0153_ sky130_fd_sc_hd__a21bo_1
XPHY_EDGE_ROW_52_Left_128 VGND VGND VPWR VPWR sky130_fd_sc_hd__decap_3
XFILLER_11_48 VGND VGND VPWR VPWR sky130_fd_sc_hd__decap_8
XFILLER_27_410 VGND VGND VPWR VPWR sky130_fd_sc_hd__decap_4
XTAP_TAPCELL_ROW_72_739 VGND VPWR sky130_fd_sc_hd__tapvpwrvgnd_1
XPHY_EDGE_ROW_61_Left_137 VGND VGND VPWR VPWR sky130_fd_sc_hd__decap_3
XFILLER_54_251 VGND VGND VPWR VPWR sky130_fd_sc_hd__fill_1
XFILLER_42_402 VGND VGND VPWR VPWR sky130_fd_sc_hd__fill_2
XFILLER_39_281 VPWR VGND VPWR VGND sky130_ef_sc_hd__decap_12
XTAP_TAPCELL_ROW_37_460 VGND VPWR sky130_fd_sc_hd__tapvpwrvgnd_1
XFILLER_36_78 VGND VGND VPWR VPWR sky130_fd_sc_hd__decap_6
XFILLER_36_23 VGND VGND VPWR VPWR sky130_fd_sc_hd__decap_4
XFILLER_14_126 VPWR VGND VPWR VGND sky130_ef_sc_hd__decap_12
XPHY_EDGE_ROW_70_Left_146 VGND VGND VPWR VPWR sky130_fd_sc_hd__decap_3
XFILLER_52_77 VGND VGND VPWR VPWR sky130_fd_sc_hd__decap_6
XFILLER_52_66 VGND VGND VPWR VPWR sky130_fd_sc_hd__decap_3
XFILLER_10_365 VPWR VGND VPWR VGND sky130_ef_sc_hd__decap_12
XFILLER_18_421 VPWR VGND VPWR VGND sky130_ef_sc_hd__decap_12
XFILLER_60_210 VPWR VGND VPWR VGND sky130_ef_sc_hd__decap_12
X_0932_ scratch\[0\]\[15\] net226 _0678_ net258 net250 VGND VGND VPWR VPWR _0679_
+ sky130_fd_sc_hd__a221o_1
XFILLER_9_141 VPWR VGND VPWR VGND sky130_ef_sc_hd__decap_12
XFILLER_61_3 VPWR VGND VPWR VGND sky130_ef_sc_hd__decap_12
X_0863_ scratch\[0\]\[4\] net223 net214 scratch\[1\]\[4\] net248 VGND VGND VPWR VPWR
+ _0621_ sky130_fd_sc_hd__a221o_1
XFILLER_5_391 VGND VGND VPWR VPWR sky130_fd_sc_hd__fill_1
XFILLER_68_365 VPWR VGND VPWR VGND sky130_ef_sc_hd__decap_12
XFILLER_68_332 VGND VGND VPWR VPWR sky130_fd_sc_hd__decap_6
X_1415_ scratch\[0\]\[18\] scratch\[0\]\[19\] scratch\[0\]\[20\] _0401_ VGND VGND
+ VPWR VPWR _0409_ sky130_fd_sc_hd__and4_1
X_1346_ _0348_ _0355_ scratch\[0\]\[3\] VGND VGND VPWR VPWR _0357_ sky130_fd_sc_hd__o21bai_1
XFILLER_3_93 VPWR VGND VPWR VGND sky130_ef_sc_hd__decap_12
XFILLER_51_254 VGND VGND VPWR VPWR sky130_fd_sc_hd__fill_1
XFILLER_51_210 VPWR VGND VPWR VGND sky130_ef_sc_hd__decap_12
X_1277_ net245 net166 scratch\[7\]\[16\] VGND VGND VPWR VPWR _0317_ sky130_fd_sc_hd__or3b_1
XFILLER_36_284 VPWR VGND VPWR VGND sky130_ef_sc_hd__decap_12
Xfanout131 _0787_ VGND VGND VPWR VPWR net131 sky130_fd_sc_hd__clkbuf_2
Xfanout120 _0359_ VGND VGND VPWR VPWR net120 sky130_fd_sc_hd__clkbuf_2
XFILLER_3_317 VPWR VGND VPWR VGND sky130_ef_sc_hd__decap_12
XFILLER_74_357 VGND VGND VPWR VPWR sky130_fd_sc_hd__decap_6
XFILLER_59_343 VGND VGND VPWR VPWR sky130_fd_sc_hd__fill_1
Xfanout186 net187 VGND VGND VPWR VPWR net186 sky130_fd_sc_hd__buf_2
XFILLER_47_55 VGND VGND VPWR VPWR sky130_fd_sc_hd__fill_1
Xfanout164 net168 VGND VGND VPWR VPWR net164 sky130_fd_sc_hd__clkbuf_2
Xfanout175 net178 VGND VGND VPWR VPWR net175 sky130_fd_sc_hd__clkbuf_2
Xfanout153 _0349_ VGND VGND VPWR VPWR net153 sky130_fd_sc_hd__clkbuf_2
Xfanout197 net203 VGND VGND VPWR VPWR net197 sky130_fd_sc_hd__buf_2
Xfanout142 net143 VGND VGND VPWR VPWR net142 sky130_fd_sc_hd__clkbuf_4
XFILLER_42_298 VGND VGND VPWR VPWR sky130_fd_sc_hd__fill_1
XFILLER_30_438 VGND VGND VPWR VPWR sky130_fd_sc_hd__decap_8
XFILLER_27_295 VGND VGND VPWR VPWR sky130_fd_sc_hd__fill_1
XFILLER_15_413 VGND VGND VPWR VPWR sky130_fd_sc_hd__fill_1
XFILLER_6_133 VGND VGND VPWR VPWR sky130_fd_sc_hd__decap_6
XFILLER_6_177 VPWR VGND VPWR VGND sky130_ef_sc_hd__decap_12
XFILLER_10_173 VGND VGND VPWR VPWR sky130_fd_sc_hd__fill_2
XFILLER_10_195 VGND VGND VPWR VPWR sky130_fd_sc_hd__fill_1
X_1200_ net240 net172 scratch\[6\]\[10\] VGND VGND VPWR VPWR _0278_ sky130_fd_sc_hd__or3b_1
XFILLER_33_7 VGND VGND VPWR VPWR sky130_fd_sc_hd__decap_3
XFILLER_65_335 VGND VGND VPWR VPWR sky130_fd_sc_hd__fill_1
X_1062_ net52 net189 net132 net345 VGND VGND VPWR VPWR _0009_ sky130_fd_sc_hd__a22o_1
XTAP_TAPCELL_ROW_48_544 VGND VPWR sky130_fd_sc_hd__tapvpwrvgnd_1
X_1131_ net41 net182 net124 net407 VGND VGND VPWR VPWR _0071_ sky130_fd_sc_hd__a22o_1
XFILLER_18_295 VGND VGND VPWR VPWR sky130_fd_sc_hd__decap_6
X_0915_ scratch\[6\]\[12\] scratch\[7\]\[12\] net271 VGND VGND VPWR VPWR _0665_ sky130_fd_sc_hd__mux2_1
XTAP_TAPCELL_ROW_31_411 VGND VPWR sky130_fd_sc_hd__tapvpwrvgnd_1
X_1895_ clknet_leaf_29_clock _0237_ VGND VGND VPWR VPWR scratch\[1\]\[2\] sky130_fd_sc_hd__dfxtp_1
XFILLER_21_449 VGND VGND VPWR VPWR sky130_fd_sc_hd__decap_4
XFILLER_0_309 VPWR VGND VPWR VGND sky130_ef_sc_hd__decap_12
X_0846_ scratch\[0\]\[1\] scratch\[2\]\[1\] scratch\[1\]\[1\] scratch\[3\]\[1\] net254
+ net264 VGND VGND VPWR VPWR _0607_ sky130_fd_sc_hd__mux4_1
XFILLER_71_305 VPWR VGND VPWR VGND sky130_ef_sc_hd__decap_12
XFILLER_68_195 VGND VGND VPWR VPWR sky130_fd_sc_hd__fill_1
X_1329_ _0577_ _0583_ net205 _0344_ VGND VGND VPWR VPWR _0169_ sky130_fd_sc_hd__o211a_1
XFILLER_17_25 VGND VGND VPWR VPWR sky130_fd_sc_hd__decap_6
XFILLER_71_349 VPWR VGND VPWR VGND sky130_ef_sc_hd__decap_12
XFILLER_24_265 VPWR VGND VPWR VGND sky130_ef_sc_hd__decap_12
XFILLER_12_449 VGND VGND VPWR VPWR sky130_fd_sc_hd__fill_1
XFILLER_33_79 VPWR VGND VPWR VGND sky130_ef_sc_hd__decap_12
XFILLER_3_125 VPWR VGND VPWR VGND sky130_ef_sc_hd__decap_12
XFILLER_59_151 VPWR VGND VPWR VGND sky130_ef_sc_hd__decap_12
XFILLER_58_54 VGND VGND VPWR VPWR sky130_fd_sc_hd__decap_6
Xhold9 scratch\[1\]\[15\] VGND VGND VPWR VPWR net285 sky130_fd_sc_hd__dlygate4sd3_1
XFILLER_3_169 VPWR VGND VPWR VGND sky130_ef_sc_hd__decap_12
XFILLER_74_165 VPWR VGND VPWR VGND sky130_ef_sc_hd__decap_12
XFILLER_74_121 VPWR VGND VPWR VGND sky130_ef_sc_hd__decap_12
XFILLER_74_97 VPWR VGND VPWR VGND sky130_ef_sc_hd__decap_12
XFILLER_74_53 VPWR VGND VPWR VGND sky130_ef_sc_hd__decap_12
XTAP_TAPCELL_ROW_45_525 VGND VPWR sky130_fd_sc_hd__tapvpwrvgnd_1
XTAP_TAPCELL_ROW_2_180 VGND VPWR sky130_fd_sc_hd__tapvpwrvgnd_1
XTAP_TAPCELL_ROW_53_591 VGND VPWR sky130_fd_sc_hd__tapvpwrvgnd_1
X_1680_ clknet_leaf_18_clock _0023_ VGND VGND VPWR VPWR scratch\[4\]\[22\] sky130_fd_sc_hd__dfxtp_1
XFILLER_38_302 VGND VGND VPWR VPWR sky130_fd_sc_hd__decap_6
XFILLER_24_3 VGND VGND VPWR VPWR sky130_fd_sc_hd__decap_6
X_1114_ net38 net187 net130 net370 VGND VGND VPWR VPWR _0057_ sky130_fd_sc_hd__a22o_1
X_1045_ net21 net4 net3 net6 VGND VGND VPWR VPWR _0775_ sky130_fd_sc_hd__or4_2
XFILLER_61_393 VPWR VGND VPWR VGND sky130_ef_sc_hd__decap_12
XFILLER_61_382 VGND VGND VPWR VPWR sky130_fd_sc_hd__decap_8
XFILLER_53_349 VPWR VGND VPWR VGND sky130_ef_sc_hd__decap_12
XFILLER_0_94 VPWR VGND VPWR VGND sky130_ef_sc_hd__decap_12
XTAP_TAPCELL_ROW_16_293 VGND VPWR sky130_fd_sc_hd__tapvpwrvgnd_1
XFILLER_21_213 VGND VGND VPWR VPWR sky130_fd_sc_hd__decap_8
X_1878_ clknet_leaf_12_clock _0220_ VGND VGND VPWR VPWR scratch\[3\]\[17\] sky130_fd_sc_hd__dfxtp_1
XFILLER_9_81 VGND VGND VPWR VPWR sky130_fd_sc_hd__decap_4
X_0829_ net253 _0586_ _0590_ VGND VGND VPWR VPWR _0591_ sky130_fd_sc_hd__a21o_1
XFILLER_29_302 VPWR VGND VPWR VGND sky130_ef_sc_hd__decap_12
XFILLER_0_106 VGND VGND VPWR VPWR sky130_fd_sc_hd__decap_6
XTAP_TAPCELL_ROW_8_228 VGND VPWR sky130_fd_sc_hd__tapvpwrvgnd_1
XFILLER_71_113 VPWR VGND VPWR VGND sky130_ef_sc_hd__decap_12
XTAP_TAPCELL_ROW_59_639 VGND VPWR sky130_fd_sc_hd__tapvpwrvgnd_1
XFILLER_44_305 VGND VGND VPWR VPWR sky130_fd_sc_hd__decap_3
XFILLER_29_335 VGND VGND VPWR VPWR sky130_fd_sc_hd__fill_1
XTAP_TAPCELL_ROW_50_561 VGND VPWR sky130_fd_sc_hd__tapvpwrvgnd_1
XFILLER_44_89 VGND VGND VPWR VPWR sky130_fd_sc_hd__fill_2
XFILLER_44_67 VGND VGND VPWR VPWR sky130_fd_sc_hd__fill_1
XFILLER_8_239 VGND VGND VPWR VPWR sky130_fd_sc_hd__fill_1
XFILLER_60_77 VGND VGND VPWR VPWR sky130_fd_sc_hd__decap_6
XFILLER_4_445 VGND VGND VPWR VPWR sky130_fd_sc_hd__decap_8
XFILLER_4_401 VPWR VGND VPWR VGND sky130_ef_sc_hd__decap_12
XPHY_EDGE_ROW_8_Left_84 VGND VGND VPWR VPWR sky130_fd_sc_hd__decap_3
XFILLER_47_165 VGND VGND VPWR VPWR sky130_fd_sc_hd__decap_3
XFILLER_43_393 VGND VGND VPWR VPWR sky130_fd_sc_hd__decap_4
X_1663_ clknet_leaf_5_clock _0006_ VGND VGND VPWR VPWR scratch\[4\]\[5\] sky130_fd_sc_hd__dfxtp_1
X_1732_ clknet_leaf_24_clock _0075_ VGND VGND VPWR VPWR scratch\[2\]\[31\] sky130_fd_sc_hd__dfxtp_1
XFILLER_7_261 VPWR VGND VPWR VGND sky130_ef_sc_hd__decap_12
X_1801_ clknet_leaf_22_clock _0144_ VGND VGND VPWR VPWR scratch\[7\]\[15\] sky130_fd_sc_hd__dfxtp_1
X_1594_ scratch\[3\]\[19\] scratch\[2\]\[19\] VGND VGND VPWR VPWR _0525_ sky130_fd_sc_hd__or2_1
XPHY_EDGE_ROW_7_Right_7 VGND VGND VPWR VPWR sky130_fd_sc_hd__decap_3
XTAP_TAPCELL_ROW_56_609 VGND VPWR sky130_fd_sc_hd__tapvpwrvgnd_1
XFILLER_53_113 VGND VGND VPWR VPWR sky130_fd_sc_hd__decap_8
XFILLER_38_121 VGND VGND VPWR VPWR sky130_fd_sc_hd__fill_1
XFILLER_26_305 VGND VGND VPWR VPWR sky130_fd_sc_hd__decap_3
XTAP_TAPCELL_ROW_64_675 VGND VPWR sky130_fd_sc_hd__tapvpwrvgnd_1
XFILLER_41_319 VGND VGND VPWR VPWR sky130_fd_sc_hd__fill_2
X_1028_ net249 _0756_ _0759_ net206 VGND VGND VPWR VPWR net98 sky130_fd_sc_hd__o211a_1
XFILLER_30_58 VGND VGND VPWR VPWR sky130_fd_sc_hd__decap_3
XFILLER_39_67 VPWR VGND VPWR VGND sky130_ef_sc_hd__decap_12
XFILLER_72_433 VPWR VGND VPWR VGND sky130_ef_sc_hd__decap_12
XFILLER_29_165 VGND VGND VPWR VPWR sky130_fd_sc_hd__decap_3
XTAP_TAPCELL_ROW_27_377 VGND VPWR sky130_fd_sc_hd__tapvpwrvgnd_1
XFILLER_25_393 VPWR VGND VPWR VGND sky130_ef_sc_hd__decap_12
XTAP_TAPCELL_ROW_10_244 VGND VPWR sky130_fd_sc_hd__tapvpwrvgnd_1
XFILLER_4_253 VPWR VGND VPWR VGND sky130_ef_sc_hd__decap_12
XFILLER_48_452 VGND VGND VPWR VPWR sky130_fd_sc_hd__fill_1
XFILLER_35_113 VGND VGND VPWR VPWR sky130_fd_sc_hd__decap_4
XTAP_TAPCELL_ROW_18_311 VGND VPWR sky130_fd_sc_hd__tapvpwrvgnd_1
XFILLER_50_138 VGND VGND VPWR VPWR sky130_fd_sc_hd__fill_2
X_1715_ clknet_leaf_19_clock _0058_ VGND VGND VPWR VPWR scratch\[5\]\[25\] sky130_fd_sc_hd__dfxtp_1
X_1646_ net43 _0566_ net139 VGND VGND VPWR VPWR _0567_ sky130_fd_sc_hd__mux2_1
XTAP_TAPCELL_ROW_69_712 VGND VPWR sky130_fd_sc_hd__tapvpwrvgnd_1
XFILLER_58_227 VGND VGND VPWR VPWR sky130_fd_sc_hd__decap_3
X_1577_ net285 net109 _0511_ VGND VGND VPWR VPWR _0250_ sky130_fd_sc_hd__a21o_1
XFILLER_66_271 VGND VGND VPWR VPWR sky130_fd_sc_hd__fill_1
XFILLER_54_411 VGND VGND VPWR VPWR sky130_fd_sc_hd__decap_8
XFILLER_54_400 VGND VGND VPWR VPWR sky130_fd_sc_hd__decap_4
XFILLER_26_179 VGND VGND VPWR VPWR sky130_fd_sc_hd__decap_8
XFILLER_26_124 VGND VGND VPWR VPWR sky130_fd_sc_hd__decap_6
XFILLER_41_13 VPWR VGND VPWR VGND sky130_ef_sc_hd__decap_12
XTAP_TAPCELL_ROW_24_358 VGND VPWR sky130_fd_sc_hd__tapvpwrvgnd_1
XFILLER_22_330 VGND VGND VPWR VPWR sky130_fd_sc_hd__decap_4
XFILLER_49_205 VGND VGND VPWR VPWR sky130_fd_sc_hd__fill_1
XFILLER_1_223 VGND VGND VPWR VPWR sky130_fd_sc_hd__fill_1
XFILLER_66_65 VPWR VGND VPWR VGND sky130_ef_sc_hd__decap_12
XFILLER_57_293 VGND VGND VPWR VPWR sky130_fd_sc_hd__decap_3
XFILLER_2_29 VPWR VGND VPWR VGND sky130_ef_sc_hd__decap_12
XFILLER_17_113 VGND VGND VPWR VPWR sky130_fd_sc_hd__fill_2
XFILLER_9_334 VGND VGND VPWR VPWR sky130_fd_sc_hd__fill_2
XFILLER_13_385 VGND VGND VPWR VPWR sky130_fd_sc_hd__decap_6
XFILLER_17_157 VGND VGND VPWR VPWR sky130_fd_sc_hd__decap_8
X_1500_ net197 _0448_ _0449_ VGND VGND VPWR VPWR _0450_ sky130_fd_sc_hd__and3_1
X_1362_ net50 net154 net117 _0369_ VGND VGND VPWR VPWR _0177_ sky130_fd_sc_hd__a22o_1
Xoutput90 net90 VGND VGND VPWR VPWR host_output_data[23] sky130_fd_sc_hd__buf_2
X_1431_ _0358_ _0418_ _0420_ VGND VGND VPWR VPWR _0422_ sky130_fd_sc_hd__or3b_1
X_1293_ net244 net165 scratch\[7\]\[24\] VGND VGND VPWR VPWR _0325_ sky130_fd_sc_hd__or3b_1
XFILLER_63_252 VGND VGND VPWR VPWR sky130_fd_sc_hd__decap_3
XFILLER_51_447 VGND VGND VPWR VPWR sky130_fd_sc_hd__fill_1
XFILLER_36_433 VGND VGND VPWR VPWR sky130_fd_sc_hd__decap_8
XTAP_TAPCELL_ROW_21_328 VGND VPWR sky130_fd_sc_hd__tapvpwrvgnd_1
XFILLER_11_38 VGND VGND VPWR VPWR sky130_fd_sc_hd__fill_2
X_1629_ scratch\[3\]\[26\] scratch\[2\]\[26\] VGND VGND VPWR VPWR _0553_ sky130_fd_sc_hd__or2_1
XFILLER_39_293 VPWR VGND VPWR VGND sky130_ef_sc_hd__decap_12
XFILLER_39_260 VGND VGND VPWR VPWR sky130_fd_sc_hd__decap_3
XFILLER_27_422 VPWR VGND VPWR VGND sky130_ef_sc_hd__decap_12
XTAP_TAPCELL_ROW_37_461 VGND VPWR sky130_fd_sc_hd__tapvpwrvgnd_1
XFILLER_14_138 VGND VGND VPWR VPWR sky130_fd_sc_hd__fill_2
XFILLER_10_377 VPWR VGND VPWR VGND sky130_ef_sc_hd__decap_12
XFILLER_60_222 VPWR VGND VPWR VGND sky130_ef_sc_hd__decap_12
XFILLER_45_285 VGND VGND VPWR VPWR sky130_fd_sc_hd__decap_6
XFILLER_18_433 VPWR VGND VPWR VGND sky130_ef_sc_hd__decap_12
X_0862_ scratch\[2\]\[4\] scratch\[3\]\[4\] net264 VGND VGND VPWR VPWR _0620_ sky130_fd_sc_hd__mux2_1
X_0931_ scratch\[2\]\[15\] scratch\[3\]\[15\] net268 VGND VGND VPWR VPWR _0678_ sky130_fd_sc_hd__mux2_1
XFILLER_9_153 VPWR VGND VPWR VGND sky130_ef_sc_hd__decap_12
XFILLER_20_108 VGND VGND VPWR VPWR sky130_fd_sc_hd__fill_1
XFILLER_54_3 VPWR VGND VPWR VGND sky130_ef_sc_hd__decap_12
XPHY_EDGE_ROW_21_Left_97 VGND VGND VPWR VPWR sky130_fd_sc_hd__decap_3
XFILLER_68_377 VPWR VGND VPWR VGND sky130_ef_sc_hd__decap_12
X_1414_ net150 _0406_ scratch\[0\]\[20\] VGND VGND VPWR VPWR _0408_ sky130_fd_sc_hd__a21oi_1
X_1345_ net441 _0348_ _0356_ VGND VGND VPWR VPWR _0173_ sky130_fd_sc_hd__a21o_1
X_1276_ net28 net165 _0316_ VGND VGND VPWR VPWR _0144_ sky130_fd_sc_hd__a21bo_1
XFILLER_51_277 VGND VGND VPWR VPWR sky130_fd_sc_hd__decap_3
XFILLER_51_266 VGND VGND VPWR VPWR sky130_fd_sc_hd__decap_4
XFILLER_51_222 VGND VGND VPWR VPWR sky130_fd_sc_hd__fill_2
XFILLER_36_296 VGND VGND VPWR VPWR sky130_fd_sc_hd__fill_1
XFILLER_36_263 VGND VGND VPWR VPWR sky130_fd_sc_hd__decap_4
XFILLER_24_425 VGND VGND VPWR VPWR sky130_fd_sc_hd__fill_1
XFILLER_51_299 VPWR VGND VPWR VGND sky130_ef_sc_hd__decap_12
Xfanout154 net155 VGND VGND VPWR VPWR net154 sky130_fd_sc_hd__buf_2
Xfanout132 net133 VGND VGND VPWR VPWR net132 sky130_fd_sc_hd__buf_2
Xfanout110 net111 VGND VGND VPWR VPWR net110 sky130_fd_sc_hd__clkbuf_4
Xfanout121 net126 VGND VGND VPWR VPWR net121 sky130_fd_sc_hd__buf_2
XFILLER_3_329 VGND VGND VPWR VPWR sky130_fd_sc_hd__decap_6
Xfanout165 net168 VGND VGND VPWR VPWR net165 sky130_fd_sc_hd__clkbuf_2
Xfanout143 net146 VGND VGND VPWR VPWR net143 sky130_fd_sc_hd__clkbuf_4
Xfanout176 net178 VGND VGND VPWR VPWR net176 sky130_fd_sc_hd__clkbuf_2
Xfanout198 net200 VGND VGND VPWR VPWR net198 sky130_fd_sc_hd__clkbuf_2
Xfanout187 net188 VGND VGND VPWR VPWR net187 sky130_fd_sc_hd__clkbuf_4
XFILLER_63_55 VGND VGND VPWR VPWR sky130_fd_sc_hd__fill_1
XFILLER_42_233 VGND VGND VPWR VPWR sky130_fd_sc_hd__fill_1
XFILLER_30_417 VGND VGND VPWR VPWR sky130_fd_sc_hd__decap_3
XFILLER_10_141 VPWR VGND VPWR VGND sky130_ef_sc_hd__decap_12
XFILLER_6_189 VGND VGND VPWR VPWR sky130_fd_sc_hd__decap_6
X_1130_ net40 net181 net123 net414 VGND VGND VPWR VPWR _0070_ sky130_fd_sc_hd__a22o_1
XFILLER_73_391 VGND VGND VPWR VPWR sky130_fd_sc_hd__fill_1
X_1061_ net51 net189 net132 net365 VGND VGND VPWR VPWR _0008_ sky130_fd_sc_hd__a22o_1
XTAP_TAPCELL_ROW_48_545 VGND VPWR sky130_fd_sc_hd__tapvpwrvgnd_1
X_0914_ scratch\[0\]\[12\] scratch\[2\]\[12\] scratch\[1\]\[12\] scratch\[3\]\[12\]
+ net261 net271 VGND VGND VPWR VPWR _0664_ sky130_fd_sc_hd__mux4_1
XTAP_TAPCELL_ROW_31_412 VGND VPWR sky130_fd_sc_hd__tapvpwrvgnd_1
X_0845_ scratch\[4\]\[1\] net222 net213 scratch\[5\]\[1\] net231 VGND VGND VPWR VPWR
+ _0606_ sky130_fd_sc_hd__a221o_1
X_1894_ clknet_leaf_28_clock _0236_ VGND VGND VPWR VPWR scratch\[1\]\[1\] sky130_fd_sc_hd__dfxtp_1
Xclkbuf_2_0__f_clock clknet_0_clock VGND VGND VPWR VPWR clknet_2_0__leaf_clock sky130_fd_sc_hd__clkbuf_16
XFILLER_71_317 VPWR VGND VPWR VGND sky130_ef_sc_hd__decap_12
XFILLER_68_141 VPWR VGND VPWR VGND sky130_ef_sc_hd__decap_12
X_1259_ net241 net161 scratch\[7\]\[7\] VGND VGND VPWR VPWR _0308_ sky130_fd_sc_hd__or3b_1
XFILLER_56_325 VGND VGND VPWR VPWR sky130_fd_sc_hd__fill_1
X_1328_ cycle_count\[2\] _0582_ net442 VGND VGND VPWR VPWR _0344_ sky130_fd_sc_hd__a21o_1
XFILLER_24_277 VGND VGND VPWR VPWR sky130_fd_sc_hd__fill_2
XFILLER_24_244 VGND VGND VPWR VPWR sky130_fd_sc_hd__decap_8
XFILLER_3_137 VPWR VGND VPWR VGND sky130_ef_sc_hd__decap_12
XFILLER_59_163 VGND VGND VPWR VPWR sky130_fd_sc_hd__decap_4
XFILLER_74_177 VPWR VGND VPWR VGND sky130_ef_sc_hd__decap_12
XFILLER_74_133 VGND VGND VPWR VPWR sky130_fd_sc_hd__decap_6
XFILLER_74_65 VPWR VGND VPWR VGND sky130_ef_sc_hd__decap_12
XFILLER_55_391 VGND VGND VPWR VPWR sky130_fd_sc_hd__fill_1
XTAP_TAPCELL_ROW_45_526 VGND VPWR sky130_fd_sc_hd__tapvpwrvgnd_1
XTAP_TAPCELL_ROW_2_181 VGND VPWR sky130_fd_sc_hd__tapvpwrvgnd_1
XFILLER_15_233 VGND VGND VPWR VPWR sky130_fd_sc_hd__decap_3
XFILLER_65_199 VPWR VGND VPWR VGND sky130_ef_sc_hd__decap_12
XFILLER_65_155 VPWR VGND VPWR VGND sky130_ef_sc_hd__decap_12
XFILLER_65_111 VGND VGND VPWR VPWR sky130_fd_sc_hd__fill_1
X_1113_ net37 net188 net129 net334 VGND VGND VPWR VPWR _0056_ sky130_fd_sc_hd__a22o_1
X_1044_ net5 net8 net7 net10 VGND VGND VPWR VPWR _0774_ sky130_fd_sc_hd__or4_2
XFILLER_17_3 VGND VGND VPWR VPWR sky130_fd_sc_hd__fill_2
XTAP_TAPCELL_ROW_16_294 VGND VPWR sky130_fd_sc_hd__tapvpwrvgnd_1
XFILLER_21_225 VGND VGND VPWR VPWR sky130_fd_sc_hd__decap_6
X_1877_ clknet_leaf_16_clock _0219_ VGND VGND VPWR VPWR scratch\[3\]\[16\] sky130_fd_sc_hd__dfxtp_1
X_0828_ scratch\[0\]\[0\] net222 net216 scratch\[1\]\[0\] net249 VGND VGND VPWR VPWR
+ _0590_ sky130_fd_sc_hd__a221o_1
XFILLER_29_325 VGND VGND VPWR VPWR sky130_fd_sc_hd__fill_1
XFILLER_29_314 VGND VGND VPWR VPWR sky130_fd_sc_hd__decap_4
XFILLER_28_25 VGND VGND VPWR VPWR sky130_fd_sc_hd__decap_3
XTAP_TAPCELL_ROW_8_229 VGND VPWR sky130_fd_sc_hd__tapvpwrvgnd_1
XFILLER_71_169 VPWR VGND VPWR VGND sky130_ef_sc_hd__decap_12
XFILLER_71_125 VPWR VGND VPWR VGND sky130_ef_sc_hd__decap_12
XFILLER_56_166 VGND VGND VPWR VPWR sky130_fd_sc_hd__decap_8
XFILLER_37_391 VGND VGND VPWR VPWR sky130_fd_sc_hd__fill_1
XTAP_TAPCELL_ROW_50_562 VGND VPWR sky130_fd_sc_hd__tapvpwrvgnd_1
XFILLER_5_18 VPWR VGND VPWR VGND sky130_ef_sc_hd__decap_12
XFILLER_4_413 VGND VGND VPWR VPWR sky130_fd_sc_hd__decap_6
X_1800_ clknet_leaf_7_clock _0143_ VGND VGND VPWR VPWR scratch\[7\]\[14\] sky130_fd_sc_hd__dfxtp_1
X_1662_ clknet_leaf_1_clock _0005_ VGND VGND VPWR VPWR scratch\[4\]\[4\] sky130_fd_sc_hd__dfxtp_1
X_1731_ clknet_leaf_24_clock _0074_ VGND VGND VPWR VPWR scratch\[2\]\[30\] sky130_fd_sc_hd__dfxtp_1
XFILLER_7_273 VGND VGND VPWR VPWR sky130_fd_sc_hd__decap_6
XTAP_TAPCELL_ROW_13_264 VGND VPWR sky130_fd_sc_hd__tapvpwrvgnd_1
X_1593_ scratch\[3\]\[19\] scratch\[2\]\[19\] VGND VGND VPWR VPWR _0524_ sky130_fd_sc_hd__nand2_1
XFILLER_38_111 VGND VGND VPWR VPWR sky130_fd_sc_hd__fill_1
XTAP_TAPCELL_ROW_64_676 VGND VPWR sky130_fd_sc_hd__tapvpwrvgnd_1
XFILLER_53_169 VPWR VGND VPWR VGND sky130_ef_sc_hd__decap_12
XFILLER_38_188 VGND VGND VPWR VPWR sky130_fd_sc_hd__decap_8
XFILLER_38_166 VGND VGND VPWR VPWR sky130_fd_sc_hd__decap_8
X_1027_ net253 _0757_ _0758_ VGND VGND VPWR VPWR _0759_ sky130_fd_sc_hd__a21o_1
XFILLER_14_27 VGND VGND VPWR VPWR sky130_fd_sc_hd__fill_1
XFILLER_1_449 VGND VGND VPWR VPWR sky130_fd_sc_hd__decap_4
XFILLER_1_405 VPWR VGND VPWR VGND sky130_ef_sc_hd__decap_12
XFILLER_72_401 VPWR VGND VPWR VGND sky130_ef_sc_hd__decap_12
XFILLER_39_79 VPWR VGND VPWR VGND sky130_ef_sc_hd__decap_12
XFILLER_39_57 VGND VGND VPWR VPWR sky130_fd_sc_hd__fill_2
XFILLER_29_177 VPWR VGND VPWR VGND sky130_ef_sc_hd__decap_12
XFILLER_29_111 VGND VGND VPWR VPWR sky130_fd_sc_hd__fill_1
XFILLER_72_445 VGND VGND VPWR VPWR sky130_fd_sc_hd__decap_8
XFILLER_71_55 VGND VGND VPWR VPWR sky130_fd_sc_hd__fill_1
XFILLER_40_320 VPWR VGND VPWR VGND sky130_ef_sc_hd__decap_12
XFILLER_32_309 VGND VGND VPWR VPWR sky130_fd_sc_hd__decap_8
XTAP_TAPCELL_ROW_27_378 VGND VPWR sky130_fd_sc_hd__tapvpwrvgnd_1
XFILLER_25_383 VGND VGND VPWR VPWR sky130_fd_sc_hd__decap_8
XFILLER_4_221 VPWR VGND VPWR VGND sky130_ef_sc_hd__decap_12
XTAP_TAPCELL_ROW_10_245 VGND VPWR sky130_fd_sc_hd__tapvpwrvgnd_1
XFILLER_4_265 VPWR VGND VPWR VGND sky130_ef_sc_hd__decap_12
Xhold90 scratch\[5\]\[10\] VGND VGND VPWR VPWR net366 sky130_fd_sc_hd__dlygate4sd3_1
XFILLER_31_386 VGND VGND VPWR VPWR sky130_fd_sc_hd__decap_6
X_1576_ net28 _0510_ net139 VGND VGND VPWR VPWR _0511_ sky130_fd_sc_hd__mux2_1
X_1645_ net198 _0564_ _0565_ VGND VGND VPWR VPWR _0566_ sky130_fd_sc_hd__and3_1
XFILLER_6_83 VGND VGND VPWR VPWR sky130_fd_sc_hd__fill_1
X_1714_ clknet_leaf_21_clock _0057_ VGND VGND VPWR VPWR scratch\[5\]\[24\] sky130_fd_sc_hd__dfxtp_1
XTAP_TAPCELL_ROW_69_713 VGND VPWR sky130_fd_sc_hd__tapvpwrvgnd_1
XFILLER_39_442 VGND VGND VPWR VPWR sky130_fd_sc_hd__decap_6
XFILLER_41_117 VPWR VGND VPWR VGND sky130_ef_sc_hd__decap_12
XTAP_TAPCELL_ROW_24_359 VGND VPWR sky130_fd_sc_hd__tapvpwrvgnd_1
XFILLER_14_309 VGND VGND VPWR VPWR sky130_fd_sc_hd__decap_3
XFILLER_41_25 VPWR VGND VPWR VGND sky130_ef_sc_hd__decap_12
XFILLER_49_217 VGND VGND VPWR VPWR sky130_fd_sc_hd__decap_6
XFILLER_1_279 VGND VGND VPWR VPWR sky130_fd_sc_hd__fill_1
XFILLER_72_253 VPWR VGND VPWR VGND sky130_ef_sc_hd__decap_12
XFILLER_66_77 VGND VGND VPWR VPWR sky130_fd_sc_hd__decap_6
XFILLER_57_261 VPWR VGND VPWR VGND sky130_ef_sc_hd__decap_12
XFILLER_17_169 VGND VGND VPWR VPWR sky130_fd_sc_hd__decap_8
XFILLER_32_117 VGND VGND VPWR VPWR sky130_fd_sc_hd__decap_3
X_1430_ _0371_ _0395_ _0419_ VGND VGND VPWR VPWR _0421_ sky130_fd_sc_hd__and3_1
XFILLER_31_91 VPWR VGND VPWR VGND sky130_ef_sc_hd__decap_12
Xoutput80 net80 VGND VGND VPWR VPWR host_output_data[14] sky130_fd_sc_hd__buf_2
XFILLER_48_250 VGND VGND VPWR VPWR sky130_fd_sc_hd__fill_2
X_1361_ _0367_ _0368_ VGND VGND VPWR VPWR _0369_ sky130_fd_sc_hd__nor2_1
X_1292_ net37 net167 _0324_ VGND VGND VPWR VPWR _0152_ sky130_fd_sc_hd__a21bo_1
Xoutput91 net91 VGND VGND VPWR VPWR host_output_data[24] sky130_fd_sc_hd__buf_2
XFILLER_63_297 VGND VGND VPWR VPWR sky130_fd_sc_hd__decap_6
XFILLER_63_242 VGND VGND VPWR VPWR sky130_fd_sc_hd__decap_3
XFILLER_23_106 VGND VGND VPWR VPWR sky130_fd_sc_hd__fill_1
XTAP_TAPCELL_ROW_21_329 VGND VPWR sky130_fd_sc_hd__tapvpwrvgnd_1
X_1559_ scratch\[3\]\[12\] scratch\[2\]\[12\] VGND VGND VPWR VPWR _0497_ sky130_fd_sc_hd__or2_1
X_1628_ scratch\[3\]\[26\] scratch\[2\]\[26\] VGND VGND VPWR VPWR _0552_ sky130_fd_sc_hd__nand2_1
XFILLER_54_253 VGND VGND VPWR VPWR sky130_fd_sc_hd__decap_4
XFILLER_46_209 VPWR VGND VPWR VGND sky130_ef_sc_hd__decap_12
XFILLER_27_434 VGND VGND VPWR VPWR sky130_fd_sc_hd__decap_6
XFILLER_42_448 VGND VGND VPWR VPWR sky130_fd_sc_hd__fill_1
XTAP_TAPCELL_ROW_37_462 VGND VPWR sky130_fd_sc_hd__tapvpwrvgnd_1
XFILLER_10_389 VPWR VGND VPWR VGND sky130_ef_sc_hd__decap_12
XTAP_TAPCELL_ROW_71_730 VGND VPWR sky130_fd_sc_hd__tapvpwrvgnd_1
XFILLER_60_245 VGND VGND VPWR VPWR sky130_fd_sc_hd__fill_1
XFILLER_45_242 VGND VGND VPWR VPWR sky130_fd_sc_hd__decap_6
XFILLER_18_445 VGND VGND VPWR VPWR sky130_fd_sc_hd__decap_8
X_0930_ net252 _0674_ _0677_ net207 VGND VGND VPWR VPWR net80 sky130_fd_sc_hd__o211a_1
X_0861_ net206 _0616_ _0619_ _0601_ net72 VGND VGND VPWR VPWR net100 sky130_fd_sc_hd__a32o_1
XFILLER_9_165 VGND VGND VPWR VPWR sky130_fd_sc_hd__decap_3
X_1413_ net32 net156 net119 _0407_ VGND VGND VPWR VPWR _0190_ sky130_fd_sc_hd__a22o_1
XFILLER_47_3 VGND VGND VPWR VPWR sky130_fd_sc_hd__decap_4
XFILLER_5_393 VPWR VGND VPWR VGND sky130_ef_sc_hd__decap_12
XFILLER_68_389 VPWR VGND VPWR VGND sky130_ef_sc_hd__decap_12
XFILLER_28_209 VGND VGND VPWR VPWR sky130_fd_sc_hd__fill_2
X_1344_ net194 _0354_ _0355_ net155 net44 VGND VGND VPWR VPWR _0356_ sky130_fd_sc_hd__a32o_1
XFILLER_3_51 VGND VGND VPWR VPWR sky130_fd_sc_hd__decap_4
X_1275_ net244 net165 scratch\[7\]\[15\] VGND VGND VPWR VPWR _0316_ sky130_fd_sc_hd__or3b_1
XTAP_TAPCELL_ROW_34_432 VGND VPWR sky130_fd_sc_hd__tapvpwrvgnd_1
XFILLER_22_27 VGND VGND VPWR VPWR sky130_fd_sc_hd__fill_1
XFILLER_59_367 VGND VGND VPWR VPWR sky130_fd_sc_hd__decap_8
Xfanout122 net126 VGND VGND VPWR VPWR net122 sky130_fd_sc_hd__clkbuf_2
Xfanout177 net178 VGND VGND VPWR VPWR net177 sky130_fd_sc_hd__clkbuf_2
Xfanout166 net168 VGND VGND VPWR VPWR net166 sky130_fd_sc_hd__clkbuf_2
Xfanout199 net200 VGND VGND VPWR VPWR net199 sky130_fd_sc_hd__clkbuf_2
Xfanout133 net136 VGND VGND VPWR VPWR net133 sky130_fd_sc_hd__buf_2
Xfanout144 net145 VGND VGND VPWR VPWR net144 sky130_fd_sc_hd__buf_2
Xfanout111 _0447_ VGND VGND VPWR VPWR net111 sky130_fd_sc_hd__clkbuf_2
Xfanout155 net158 VGND VGND VPWR VPWR net155 sky130_fd_sc_hd__clkbuf_2
Xfanout188 _0785_ VGND VGND VPWR VPWR net188 sky130_fd_sc_hd__clkbuf_4
XFILLER_47_57 VGND VGND VPWR VPWR sky130_fd_sc_hd__decap_6
XPHY_EDGE_ROW_29_Right_29 VGND VGND VPWR VPWR sky130_fd_sc_hd__decap_3
XPHY_EDGE_ROW_38_Right_38 VGND VGND VPWR VPWR sky130_fd_sc_hd__decap_3
XFILLER_30_429 VGND VGND VPWR VPWR sky130_fd_sc_hd__fill_1
XFILLER_8_18 VGND VGND VPWR VPWR sky130_fd_sc_hd__decap_8
XFILLER_8_29 VPWR VGND VPWR VGND sky130_ef_sc_hd__decap_12
XFILLER_10_153 VPWR VGND VPWR VGND sky130_ef_sc_hd__decap_12
XFILLER_2_363 VGND VGND VPWR VPWR sky130_fd_sc_hd__fill_1
XFILLER_10_197 VGND VGND VPWR VPWR sky130_fd_sc_hd__decap_6
XFILLER_65_359 VPWR VGND VPWR VGND sky130_ef_sc_hd__decap_12
XFILLER_65_337 VPWR VGND VPWR VGND sky130_ef_sc_hd__decap_12
XFILLER_65_315 VPWR VGND VPWR VGND sky130_ef_sc_hd__decap_12
XTAP_TAPCELL_ROW_48_546 VGND VPWR sky130_fd_sc_hd__tapvpwrvgnd_1
XPHY_EDGE_ROW_47_Right_47 VGND VGND VPWR VPWR sky130_fd_sc_hd__decap_3
X_1060_ net50 net189 net132 net367 VGND VGND VPWR VPWR _0007_ sky130_fd_sc_hd__a22o_1
XPHY_EDGE_ROW_56_Right_56 VGND VGND VPWR VPWR sky130_fd_sc_hd__decap_3
XFILLER_33_278 VGND VGND VPWR VPWR sky130_fd_sc_hd__fill_2
XFILLER_33_223 VGND VGND VPWR VPWR sky130_fd_sc_hd__fill_1
XTAP_TAPCELL_ROW_31_413 VGND VPWR sky130_fd_sc_hd__tapvpwrvgnd_1
X_0913_ net209 _0660_ _0663_ VGND VGND VPWR VPWR net77 sky130_fd_sc_hd__and3_1
X_0844_ net254 _0604_ VGND VGND VPWR VPWR _0605_ sky130_fd_sc_hd__and2_1
X_1893_ clknet_leaf_27_clock _0235_ VGND VGND VPWR VPWR scratch\[1\]\[0\] sky130_fd_sc_hd__dfxtp_1
XFILLER_68_153 VGND VGND VPWR VPWR sky130_fd_sc_hd__decap_3
XPHY_EDGE_ROW_65_Right_65 VGND VGND VPWR VPWR sky130_fd_sc_hd__decap_3
XFILLER_71_329 VGND VGND VPWR VPWR sky130_fd_sc_hd__decap_6
XFILLER_68_197 VGND VGND VPWR VPWR sky130_fd_sc_hd__fill_2
X_1258_ net50 net161 _0307_ VGND VGND VPWR VPWR _0135_ sky130_fd_sc_hd__a21bo_1
X_1189_ net48 net172 _0272_ VGND VGND VPWR VPWR _0101_ sky130_fd_sc_hd__a21bo_1
X_1327_ net440 _0582_ _0343_ VGND VGND VPWR VPWR _0168_ sky130_fd_sc_hd__a21oi_1
XPHY_EDGE_ROW_74_Right_74 VGND VGND VPWR VPWR sky130_fd_sc_hd__decap_3
XPHY_EDGE_ROW_49_Left_125 VGND VGND VPWR VPWR sky130_fd_sc_hd__decap_3
XFILLER_12_429 VPWR VGND VPWR VGND sky130_ef_sc_hd__decap_12
XFILLER_3_149 VPWR VGND VPWR VGND sky130_ef_sc_hd__decap_12
XFILLER_3_105 VGND VGND VPWR VPWR sky130_fd_sc_hd__decap_6
XFILLER_59_186 VPWR VGND VPWR VGND sky130_ef_sc_hd__decap_12
XFILLER_58_89 VGND VGND VPWR VPWR sky130_fd_sc_hd__fill_1
XFILLER_58_78 VGND VGND VPWR VPWR sky130_fd_sc_hd__decap_6
XFILLER_58_45 VGND VGND VPWR VPWR sky130_fd_sc_hd__fill_1
XPHY_EDGE_ROW_58_Left_134 VGND VGND VPWR VPWR sky130_fd_sc_hd__decap_3
XFILLER_47_348 VGND VGND VPWR VPWR sky130_fd_sc_hd__fill_1
XFILLER_74_189 VGND VGND VPWR VPWR sky130_fd_sc_hd__decap_6
XFILLER_74_77 VGND VGND VPWR VPWR sky130_fd_sc_hd__decap_6
XPHY_EDGE_ROW_67_Left_143 VGND VGND VPWR VPWR sky130_fd_sc_hd__decap_3
XFILLER_62_307 VGND VGND VPWR VPWR sky130_fd_sc_hd__fill_1
XTAP_TAPCELL_ROW_45_527 VGND VPWR sky130_fd_sc_hd__tapvpwrvgnd_1
XTAP_TAPCELL_ROW_2_182 VGND VPWR sky130_fd_sc_hd__tapvpwrvgnd_1
XFILLER_15_201 VGND VGND VPWR VPWR sky130_fd_sc_hd__decap_4
XFILLER_31_6 VGND VGND VPWR VPWR sky130_fd_sc_hd__decap_3
XFILLER_65_167 VGND VGND VPWR VPWR sky130_fd_sc_hd__fill_1
X_1043_ net9 net13 net11 net54 VGND VGND VPWR VPWR _0773_ sky130_fd_sc_hd__or4b_4
X_1112_ net36 net186 net129 net322 VGND VGND VPWR VPWR _0055_ sky130_fd_sc_hd__a22o_1
XFILLER_0_41 VPWR VGND VPWR VGND sky130_ef_sc_hd__decap_12
XFILLER_0_85 VGND VGND VPWR VPWR sky130_fd_sc_hd__decap_4
XTAP_TAPCELL_ROW_16_295 VGND VPWR sky130_fd_sc_hd__tapvpwrvgnd_1
XFILLER_21_248 VGND VGND VPWR VPWR sky130_fd_sc_hd__decap_4
X_1876_ clknet_leaf_16_clock _0218_ VGND VGND VPWR VPWR scratch\[3\]\[15\] sky130_fd_sc_hd__dfxtp_1
X_0827_ net213 VGND VGND VPWR VPWR _0589_ sky130_fd_sc_hd__inv_2
XFILLER_29_348 VPWR VGND VPWR VGND sky130_ef_sc_hd__decap_12
XFILLER_71_137 VPWR VGND VPWR VGND sky130_ef_sc_hd__decap_12
XTAP_TAPCELL_ROW_67_696 VGND VPWR sky130_fd_sc_hd__tapvpwrvgnd_1
XFILLER_44_58 VGND VGND VPWR VPWR sky130_fd_sc_hd__decap_3
XFILLER_44_25 VGND VGND VPWR VPWR sky130_fd_sc_hd__decap_3
XTAP_TAPCELL_ROW_50_563 VGND VPWR sky130_fd_sc_hd__tapvpwrvgnd_1
XFILLER_12_259 VGND VGND VPWR VPWR sky130_fd_sc_hd__fill_1
XFILLER_69_55 VGND VGND VPWR VPWR sky130_fd_sc_hd__fill_1
XFILLER_75_421 VPWR VGND VPWR VGND sky130_ef_sc_hd__decap_12
XFILLER_62_115 VGND VGND VPWR VPWR sky130_fd_sc_hd__decap_6
XTAP_TAPCELL_ROW_58_630 VGND VPWR sky130_fd_sc_hd__tapvpwrvgnd_1
XFILLER_47_101 VGND VGND VPWR VPWR sky130_fd_sc_hd__decap_8
XFILLER_43_373 VPWR VGND VPWR VGND sky130_ef_sc_hd__decap_12
XTAP_TAPCELL_ROW_13_265 VGND VPWR sky130_fd_sc_hd__tapvpwrvgnd_1
X_1592_ net307 net109 _0523_ VGND VGND VPWR VPWR _0253_ sky130_fd_sc_hd__a21o_1
X_1730_ clknet_leaf_23_clock _0073_ VGND VGND VPWR VPWR scratch\[2\]\[29\] sky130_fd_sc_hd__dfxtp_1
XFILLER_11_281 VPWR VGND VPWR VGND sky130_ef_sc_hd__decap_12
X_1661_ clknet_leaf_26_clock _0004_ VGND VGND VPWR VPWR scratch\[4\]\[3\] sky130_fd_sc_hd__dfxtp_1
XFILLER_66_421 VPWR VGND VPWR VGND sky130_ef_sc_hd__decap_12
XFILLER_38_101 VGND VGND VPWR VPWR sky130_fd_sc_hd__fill_2
XTAP_TAPCELL_ROW_64_677 VGND VPWR sky130_fd_sc_hd__tapvpwrvgnd_1
XFILLER_53_137 VPWR VGND VPWR VGND sky130_ef_sc_hd__decap_12
XFILLER_34_395 VGND VGND VPWR VPWR sky130_fd_sc_hd__decap_6
X_1026_ scratch\[4\]\[30\] net225 net216 scratch\[5\]\[30\] net231 VGND VGND VPWR
+ VPWR _0758_ sky130_fd_sc_hd__a221o_1
XFILLER_30_27 VGND VGND VPWR VPWR sky130_fd_sc_hd__fill_1
X_1859_ clknet_leaf_24_clock _0201_ VGND VGND VPWR VPWR scratch\[0\]\[30\] sky130_fd_sc_hd__dfxtp_1
XFILLER_1_417 VPWR VGND VPWR VGND sky130_ef_sc_hd__decap_12
XFILLER_72_413 VGND VGND VPWR VPWR sky130_fd_sc_hd__decap_6
XFILLER_69_281 VPWR VGND VPWR VGND sky130_ef_sc_hd__decap_12
XTAP_TAPCELL_ROW_55_600 VGND VPWR sky130_fd_sc_hd__tapvpwrvgnd_1
XFILLER_55_57 VGND VGND VPWR VPWR sky130_fd_sc_hd__decap_6
XFILLER_55_79 VGND VGND VPWR VPWR sky130_fd_sc_hd__fill_1
XFILLER_40_332 VGND VGND VPWR VPWR sky130_fd_sc_hd__decap_8
XTAP_TAPCELL_ROW_27_379 VGND VPWR sky130_fd_sc_hd__tapvpwrvgnd_1
XFILLER_4_233 VPWR VGND VPWR VGND sky130_ef_sc_hd__decap_12
XTAP_TAPCELL_ROW_10_246 VGND VPWR sky130_fd_sc_hd__tapvpwrvgnd_1
XFILLER_4_277 VPWR VGND VPWR VGND sky130_ef_sc_hd__decap_12
XFILLER_75_262 VGND VGND VPWR VPWR sky130_fd_sc_hd__decap_8
XFILLER_75_240 VGND VGND VPWR VPWR sky130_fd_sc_hd__decap_4
Xhold80 scratch\[4\]\[14\] VGND VGND VPWR VPWR net356 sky130_fd_sc_hd__dlygate4sd3_1
Xhold91 scratch\[4\]\[6\] VGND VGND VPWR VPWR net367 sky130_fd_sc_hd__dlygate4sd3_1
X_1713_ clknet_leaf_14_clock _0056_ VGND VGND VPWR VPWR scratch\[5\]\[23\] sky130_fd_sc_hd__dfxtp_1
X_1575_ net198 _0508_ _0509_ VGND VGND VPWR VPWR _0510_ sky130_fd_sc_hd__and3_1
X_1644_ scratch\[3\]\[29\] scratch\[2\]\[29\] VGND VGND VPWR VPWR _0565_ sky130_fd_sc_hd__or2_1
XTAP_TAPCELL_ROW_69_714 VGND VPWR sky130_fd_sc_hd__tapvpwrvgnd_1
XFILLER_66_295 VPWR VGND VPWR VGND sky130_ef_sc_hd__decap_12
XFILLER_41_129 VPWR VGND VPWR VGND sky130_ef_sc_hd__decap_12
X_1009_ net251 _0740_ _0743_ net208 VGND VGND VPWR VPWR net94 sky130_fd_sc_hd__o211a_1
XFILLER_41_37 VPWR VGND VPWR VGND sky130_ef_sc_hd__decap_12
XFILLER_1_225 VPWR VGND VPWR VGND sky130_ef_sc_hd__decap_12
XFILLER_72_265 VPWR VGND VPWR VGND sky130_ef_sc_hd__decap_12
XFILLER_72_221 VPWR VGND VPWR VGND sky130_ef_sc_hd__decap_12
XFILLER_57_273 VGND VGND VPWR VPWR sky130_fd_sc_hd__decap_6
XFILLER_40_195 VGND VGND VPWR VPWR sky130_fd_sc_hd__fill_1
XFILLER_13_310 VGND VGND VPWR VPWR sky130_fd_sc_hd__fill_2
X_1360_ scratch\[0\]\[6\] net147 _0365_ VGND VGND VPWR VPWR _0368_ sky130_fd_sc_hd__and3_1
Xoutput70 net70 VGND VGND VPWR VPWR current_stage[1] sky130_fd_sc_hd__clkbuf_4
XFILLER_63_221 VGND VGND VPWR VPWR sky130_fd_sc_hd__decap_3
X_1291_ net246 net167 scratch\[7\]\[23\] VGND VGND VPWR VPWR _0324_ sky130_fd_sc_hd__or3b_1
Xoutput81 net81 VGND VGND VPWR VPWR host_output_data[15] sky130_fd_sc_hd__buf_2
Xoutput92 net92 VGND VGND VPWR VPWR host_output_data[25] sky130_fd_sc_hd__buf_2
XFILLER_51_427 VGND VGND VPWR VPWR sky130_fd_sc_hd__decap_4
XFILLER_51_405 VGND VGND VPWR VPWR sky130_fd_sc_hd__fill_1
XFILLER_23_129 VPWR VGND VPWR VGND sky130_ef_sc_hd__decap_12
XFILLER_11_18 VPWR VGND VPWR VGND sky130_ef_sc_hd__decap_12
X_1558_ scratch\[3\]\[12\] scratch\[2\]\[12\] VGND VGND VPWR VPWR _0496_ sky130_fd_sc_hd__nand2_1
X_1627_ net292 net109 _0551_ VGND VGND VPWR VPWR _0260_ sky130_fd_sc_hd__a21o_1
X_1489_ net39 net145 net114 net391 VGND VGND VPWR VPWR _0228_ sky130_fd_sc_hd__a22o_1
XFILLER_54_232 VGND VGND VPWR VPWR sky130_fd_sc_hd__decap_3
XTAP_TAPCELL_ROW_37_463 VGND VPWR sky130_fd_sc_hd__tapvpwrvgnd_1
XFILLER_54_298 VGND VGND VPWR VPWR sky130_fd_sc_hd__fill_1
XFILLER_52_25 VGND VGND VPWR VPWR sky130_fd_sc_hd__decap_3
XFILLER_42_438 VGND VGND VPWR VPWR sky130_fd_sc_hd__fill_2
XPHY_EDGE_ROW_30_Left_106 VGND VGND VPWR VPWR sky130_fd_sc_hd__decap_3
XFILLER_22_195 VGND VGND VPWR VPWR sky130_fd_sc_hd__fill_1
XFILLER_10_302 VGND VGND VPWR VPWR sky130_fd_sc_hd__decap_6
XFILLER_10_313 VGND VGND VPWR VPWR sky130_fd_sc_hd__fill_1
XFILLER_45_210 VGND VGND VPWR VPWR sky130_fd_sc_hd__decap_3
XTAP_TAPCELL_ROW_71_731 VGND VPWR sky130_fd_sc_hd__tapvpwrvgnd_1
XFILLER_33_405 VGND VGND VPWR VPWR sky130_fd_sc_hd__decap_3
X_0860_ scratch\[5\]\[3\] net213 _0618_ VGND VGND VPWR VPWR _0619_ sky130_fd_sc_hd__a21o_1
X_1412_ net150 _0406_ _0404_ scratch\[0\]\[19\] VGND VGND VPWR VPWR _0407_ sky130_fd_sc_hd__o2bb2a_1
X_1343_ scratch\[0\]\[0\] scratch\[0\]\[1\] scratch\[0\]\[2\] VGND VGND VPWR VPWR
+ _0355_ sky130_fd_sc_hd__nand3_1
XFILLER_5_361 VPWR VGND VPWR VGND sky130_ef_sc_hd__decap_12
X_1274_ net27 net162 _0315_ VGND VGND VPWR VPWR _0143_ sky130_fd_sc_hd__a21bo_1
XTAP_TAPCELL_ROW_34_433 VGND VPWR sky130_fd_sc_hd__tapvpwrvgnd_1
XFILLER_24_449 VGND VGND VPWR VPWR sky130_fd_sc_hd__decap_4
XFILLER_24_438 VGND VGND VPWR VPWR sky130_fd_sc_hd__decap_4
X_0989_ scratch\[6\]\[24\] scratch\[7\]\[24\] net268 VGND VGND VPWR VPWR _0727_ sky130_fd_sc_hd__mux2_1
Xfanout167 net168 VGND VGND VPWR VPWR net167 sky130_fd_sc_hd__clkbuf_2
Xfanout134 net135 VGND VGND VPWR VPWR net134 sky130_fd_sc_hd__buf_2
Xfanout189 net193 VGND VGND VPWR VPWR net189 sky130_fd_sc_hd__buf_2
Xfanout156 net157 VGND VGND VPWR VPWR net156 sky130_fd_sc_hd__buf_2
Xfanout145 net146 VGND VGND VPWR VPWR net145 sky130_fd_sc_hd__clkbuf_4
Xfanout123 net125 VGND VGND VPWR VPWR net123 sky130_fd_sc_hd__buf_2
Xfanout112 net116 VGND VGND VPWR VPWR net112 sky130_fd_sc_hd__clkbuf_4
Xfanout178 _0267_ VGND VGND VPWR VPWR net178 sky130_fd_sc_hd__clkbuf_4
XFILLER_63_57 VGND VGND VPWR VPWR sky130_fd_sc_hd__decap_8
XFILLER_27_265 VGND VGND VPWR VPWR sky130_fd_sc_hd__fill_1
XFILLER_27_221 VGND VGND VPWR VPWR sky130_fd_sc_hd__decap_3
XFILLER_15_405 VGND VGND VPWR VPWR sky130_fd_sc_hd__decap_8
XFILLER_10_165 VGND VGND VPWR VPWR sky130_fd_sc_hd__decap_8
XFILLER_65_349 VGND VGND VPWR VPWR sky130_fd_sc_hd__fill_1
XFILLER_65_327 VGND VGND VPWR VPWR sky130_fd_sc_hd__decap_8
XTAP_TAPCELL_ROW_48_547 VGND VPWR sky130_fd_sc_hd__tapvpwrvgnd_1
XFILLER_18_221 VGND VGND VPWR VPWR sky130_fd_sc_hd__decap_6
XFILLER_73_393 VPWR VGND VPWR VGND sky130_ef_sc_hd__decap_12
X_0912_ net261 _0661_ _0662_ VGND VGND VPWR VPWR _0663_ sky130_fd_sc_hd__a21o_1
XTAP_TAPCELL_ROW_31_414 VGND VPWR sky130_fd_sc_hd__tapvpwrvgnd_1
X_1892_ clknet_leaf_25_clock _0234_ VGND VGND VPWR VPWR scratch\[3\]\[31\] sky130_fd_sc_hd__dfxtp_1
X_0843_ scratch\[6\]\[1\] scratch\[7\]\[1\] net264 VGND VGND VPWR VPWR _0604_ sky130_fd_sc_hd__mux2_1
XFILLER_68_121 VPWR VGND VPWR VGND sky130_ef_sc_hd__decap_12
X_1326_ cycle_count\[2\] _0582_ net205 VGND VGND VPWR VPWR _0343_ sky130_fd_sc_hd__o21ai_1
X_1257_ net241 net161 scratch\[7\]\[6\] VGND VGND VPWR VPWR _0307_ sky130_fd_sc_hd__or3b_1
X_1188_ net240 net172 scratch\[6\]\[4\] VGND VGND VPWR VPWR _0272_ sky130_fd_sc_hd__or3b_1
XFILLER_24_202 VGND VGND VPWR VPWR sky130_fd_sc_hd__fill_1
XFILLER_12_419 VGND VGND VPWR VPWR sky130_fd_sc_hd__fill_1
XFILLER_59_198 VGND VGND VPWR VPWR sky130_fd_sc_hd__decap_3
XTAP_TAPCELL_ROW_2_183 VGND VPWR sky130_fd_sc_hd__tapvpwrvgnd_1
XFILLER_70_363 VGND VGND VPWR VPWR sky130_fd_sc_hd__fill_1
XFILLER_55_393 VGND VGND VPWR VPWR sky130_fd_sc_hd__decap_8
XFILLER_30_205 VGND VGND VPWR VPWR sky130_fd_sc_hd__fill_2
XFILLER_11_441 VGND VGND VPWR VPWR sky130_fd_sc_hd__decap_6
XFILLER_15_279 VGND VGND VPWR VPWR sky130_fd_sc_hd__fill_1
X_1111_ net35 net186 net131 net339 VGND VGND VPWR VPWR _0054_ sky130_fd_sc_hd__a22o_1
X_1042_ _0770_ _0771_ VGND VGND VPWR VPWR _0772_ sky130_fd_sc_hd__nor2_1
XFILLER_0_53 VGND VGND VPWR VPWR sky130_fd_sc_hd__decap_3
X_1875_ clknet_leaf_6_clock _0217_ VGND VGND VPWR VPWR scratch\[3\]\[14\] sky130_fd_sc_hd__dfxtp_1
X_0826_ net253 net263 VGND VGND VPWR VPWR _0588_ sky130_fd_sc_hd__and2b_1
XFILLER_71_105 VGND VGND VPWR VPWR sky130_fd_sc_hd__decap_6
XFILLER_69_441 VGND VGND VPWR VPWR sky130_fd_sc_hd__decap_6
X_1309_ _0576_ net67 net239 VGND VGND VPWR VPWR _0333_ sky130_fd_sc_hd__a21oi_1
XFILLER_71_149 VPWR VGND VPWR VGND sky130_ef_sc_hd__decap_12
XTAP_TAPCELL_ROW_67_697 VGND VPWR sky130_fd_sc_hd__tapvpwrvgnd_1
XFILLER_52_363 VGND VGND VPWR VPWR sky130_fd_sc_hd__fill_1
XFILLER_37_393 VPWR VGND VPWR VGND sky130_ef_sc_hd__decap_12
XFILLER_8_209 VPWR VGND VPWR VGND sky130_ef_sc_hd__decap_12
XTAP_TAPCELL_ROW_50_564 VGND VPWR sky130_fd_sc_hd__tapvpwrvgnd_1
XFILLER_20_260 VGND VGND VPWR VPWR sky130_fd_sc_hd__decap_6
XFILLER_47_113 VGND VGND VPWR VPWR sky130_fd_sc_hd__decap_3
XTAP_TAPCELL_ROW_7_220 VGND VPWR sky130_fd_sc_hd__tapvpwrvgnd_1
XFILLER_75_433 VPWR VGND VPWR VGND sky130_ef_sc_hd__decap_12
XTAP_TAPCELL_ROW_58_631 VGND VPWR sky130_fd_sc_hd__tapvpwrvgnd_1
XFILLER_18_60 VGND VGND VPWR VPWR sky130_fd_sc_hd__decap_4
XFILLER_43_385 VGND VGND VPWR VPWR sky130_fd_sc_hd__decap_6
XFILLER_11_293 VGND VGND VPWR VPWR sky130_fd_sc_hd__decap_3
XTAP_TAPCELL_ROW_13_266 VGND VPWR sky130_fd_sc_hd__tapvpwrvgnd_1
X_1591_ net31 _0522_ net139 VGND VGND VPWR VPWR _0523_ sky130_fd_sc_hd__mux2_1
X_1660_ clknet_leaf_27_clock _0003_ VGND VGND VPWR VPWR scratch\[4\]\[2\] sky130_fd_sc_hd__dfxtp_1
XFILLER_66_433 VPWR VGND VPWR VGND sky130_ef_sc_hd__decap_12
XFILLER_22_3 VGND VGND VPWR VPWR sky130_fd_sc_hd__fill_2
XTAP_TAPCELL_ROW_64_678 VGND VPWR sky130_fd_sc_hd__tapvpwrvgnd_1
XFILLER_61_182 VPWR VGND VPWR VGND sky130_ef_sc_hd__decap_12
XFILLER_53_149 VGND VGND VPWR VPWR sky130_fd_sc_hd__fill_1
XFILLER_34_374 VGND VGND VPWR VPWR sky130_fd_sc_hd__decap_6
XFILLER_34_363 VGND VGND VPWR VPWR sky130_fd_sc_hd__fill_1
X_1025_ scratch\[6\]\[30\] scratch\[7\]\[30\] net263 VGND VGND VPWR VPWR _0757_ sky130_fd_sc_hd__mux2_1
XFILLER_14_29 VPWR VGND VPWR VGND sky130_ef_sc_hd__decap_12
XFILLER_19_393 VGND VGND VPWR VPWR sky130_fd_sc_hd__decap_3
X_1858_ clknet_leaf_23_clock _0200_ VGND VGND VPWR VPWR scratch\[0\]\[29\] sky130_fd_sc_hd__dfxtp_1
XFILLER_39_48 VGND VGND VPWR VPWR sky130_fd_sc_hd__fill_1
XFILLER_39_15 VGND VGND VPWR VPWR sky130_fd_sc_hd__fill_2
XFILLER_1_429 VPWR VGND VPWR VGND sky130_ef_sc_hd__decap_12
X_1789_ clknet_leaf_27_clock _0132_ VGND VGND VPWR VPWR scratch\[7\]\[3\] sky130_fd_sc_hd__dfxtp_1
XFILLER_69_293 VPWR VGND VPWR VGND sky130_ef_sc_hd__decap_12
XTAP_TAPCELL_ROW_55_601 VGND VPWR sky130_fd_sc_hd__tapvpwrvgnd_1
XFILLER_44_127 VPWR VGND VPWR VGND sky130_ef_sc_hd__decap_12
XFILLER_29_157 VGND VGND VPWR VPWR sky130_fd_sc_hd__decap_8
XFILLER_71_57 VPWR VGND VPWR VGND sky130_ef_sc_hd__decap_12
XFILLER_4_289 VPWR VGND VPWR VGND sky130_ef_sc_hd__decap_12
XFILLER_4_245 VGND VGND VPWR VPWR sky130_fd_sc_hd__decap_6
XTAP_TAPCELL_ROW_10_247 VGND VPWR sky130_fd_sc_hd__tapvpwrvgnd_1
XFILLER_20_83 VGND VGND VPWR VPWR sky130_fd_sc_hd__fill_1
Xhold92 scratch\[4\]\[9\] VGND VGND VPWR VPWR net368 sky130_fd_sc_hd__dlygate4sd3_1
Xhold81 scratch\[4\]\[4\] VGND VGND VPWR VPWR net357 sky130_fd_sc_hd__dlygate4sd3_1
Xhold70 scratch\[4\]\[27\] VGND VGND VPWR VPWR net346 sky130_fd_sc_hd__dlygate4sd3_1
XFILLER_75_285 VGND VGND VPWR VPWR sky130_fd_sc_hd__fill_1
XFILLER_63_447 VGND VGND VPWR VPWR sky130_fd_sc_hd__fill_1
XTAP_TAPCELL_ROW_61_648 VGND VPWR sky130_fd_sc_hd__tapvpwrvgnd_1
XFILLER_35_105 VGND VGND VPWR VPWR sky130_fd_sc_hd__fill_1
X_1712_ clknet_leaf_14_clock _0055_ VGND VGND VPWR VPWR scratch\[5\]\[22\] sky130_fd_sc_hd__dfxtp_1
X_1643_ scratch\[3\]\[29\] scratch\[2\]\[29\] VGND VGND VPWR VPWR _0564_ sky130_fd_sc_hd__nand2_1
XFILLER_6_41 VPWR VGND VPWR VGND sky130_ef_sc_hd__decap_12
XANTENNA_1 _0300_ VGND VGND VPWR VPWR sky130_fd_sc_hd__diode_2
XTAP_TAPCELL_ROW_69_715 VGND VPWR sky130_fd_sc_hd__tapvpwrvgnd_1
X_1574_ scratch\[3\]\[15\] scratch\[2\]\[15\] VGND VGND VPWR VPWR _0509_ sky130_fd_sc_hd__or2_1
XFILLER_6_85 VPWR VGND VPWR VGND sky130_ef_sc_hd__decap_12
XFILLER_19_190 VGND VGND VPWR VPWR sky130_fd_sc_hd__decap_8
X_1008_ net262 _0741_ _0742_ VGND VGND VPWR VPWR _0743_ sky130_fd_sc_hd__a21o_1
XFILLER_1_237 VPWR VGND VPWR VGND sky130_ef_sc_hd__decap_12
XFILLER_72_277 VPWR VGND VPWR VGND sky130_ef_sc_hd__decap_12
XFILLER_72_233 VPWR VGND VPWR VGND sky130_ef_sc_hd__decap_12
XFILLER_45_447 VGND VGND VPWR VPWR sky130_fd_sc_hd__fill_1
XFILLER_40_141 VGND VGND VPWR VPWR sky130_fd_sc_hd__decap_6
XTAP_TAPCELL_ROW_23_350 VGND VPWR sky130_fd_sc_hd__tapvpwrvgnd_1
XFILLER_9_326 VGND VGND VPWR VPWR sky130_fd_sc_hd__decap_8
XFILLER_9_337 VPWR VGND VPWR VGND sky130_ef_sc_hd__decap_12
Xoutput82 net82 VGND VGND VPWR VPWR host_output_data[16] sky130_fd_sc_hd__buf_2
Xoutput93 net93 VGND VGND VPWR VPWR host_output_data[26] sky130_fd_sc_hd__buf_2
Xoutput71 net71 VGND VGND VPWR VPWR current_stage[2] sky130_fd_sc_hd__clkbuf_4
X_1290_ net36 net164 _0323_ VGND VGND VPWR VPWR _0151_ sky130_fd_sc_hd__a21bo_1
XFILLER_0_270 VGND VGND VPWR VPWR sky130_fd_sc_hd__fill_2
XFILLER_0_281 VPWR VGND VPWR VGND sky130_ef_sc_hd__decap_12
XFILLER_16_171 VGND VGND VPWR VPWR sky130_fd_sc_hd__fill_1
X_1626_ net39 _0550_ net139 VGND VGND VPWR VPWR _0551_ sky130_fd_sc_hd__mux2_1
X_1557_ net296 net110 _0495_ VGND VGND VPWR VPWR _0246_ sky130_fd_sc_hd__a21o_1
XFILLER_39_252 VGND VGND VPWR VPWR sky130_fd_sc_hd__decap_8
X_1488_ net38 net145 net115 net392 VGND VGND VPWR VPWR _0227_ sky130_fd_sc_hd__a22o_1
XFILLER_36_27 VGND VGND VPWR VPWR sky130_fd_sc_hd__fill_1
XFILLER_6_307 VGND VGND VPWR VPWR sky130_fd_sc_hd__fill_1
XTAP_TAPCELL_ROW_20_320 VGND VPWR sky130_fd_sc_hd__tapvpwrvgnd_1
XTAP_TAPCELL_ROW_71_732 VGND VPWR sky130_fd_sc_hd__tapvpwrvgnd_1
XFILLER_45_277 VGND VGND VPWR VPWR sky130_fd_sc_hd__decap_3
XFILLER_33_428 VGND VGND VPWR VPWR sky130_fd_sc_hd__decap_4
XFILLER_26_93 VGND VGND VPWR VPWR sky130_fd_sc_hd__fill_1
XFILLER_26_60 VPWR VGND VPWR VGND sky130_ef_sc_hd__decap_12
XFILLER_5_373 VPWR VGND VPWR VGND sky130_ef_sc_hd__decap_12
XFILLER_9_189 VPWR VGND VPWR VGND sky130_ef_sc_hd__decap_12
X_1273_ net242 net162 scratch\[7\]\[14\] VGND VGND VPWR VPWR _0315_ sky130_fd_sc_hd__or3b_1
X_1411_ scratch\[0\]\[18\] scratch\[0\]\[19\] _0401_ VGND VGND VPWR VPWR _0406_ sky130_fd_sc_hd__and3_1
X_1342_ scratch\[0\]\[0\] scratch\[0\]\[1\] scratch\[0\]\[2\] VGND VGND VPWR VPWR
+ _0354_ sky130_fd_sc_hd__a21o_1
XFILLER_51_225 VGND VGND VPWR VPWR sky130_fd_sc_hd__fill_1
XTAP_TAPCELL_ROW_34_434 VGND VPWR sky130_fd_sc_hd__tapvpwrvgnd_1
X_0988_ scratch\[0\]\[24\] scratch\[2\]\[24\] scratch\[1\]\[24\] scratch\[3\]\[24\]
+ net258 net268 VGND VGND VPWR VPWR _0726_ sky130_fd_sc_hd__mux4_1
XFILLER_22_29 VPWR VGND VPWR VGND sky130_ef_sc_hd__decap_12
Xfanout113 net116 VGND VGND VPWR VPWR net113 sky130_fd_sc_hd__buf_2
X_1609_ scratch\[3\]\[22\] scratch\[2\]\[22\] VGND VGND VPWR VPWR _0537_ sky130_fd_sc_hd__or2_1
Xfanout135 net136 VGND VGND VPWR VPWR net135 sky130_fd_sc_hd__buf_2
Xfanout179 _0789_ VGND VGND VPWR VPWR net179 sky130_fd_sc_hd__buf_2
Xfanout157 net158 VGND VGND VPWR VPWR net157 sky130_fd_sc_hd__buf_2
Xfanout124 net125 VGND VGND VPWR VPWR net124 sky130_fd_sc_hd__clkbuf_2
Xfanout146 _0444_ VGND VGND VPWR VPWR net146 sky130_fd_sc_hd__buf_2
Xfanout168 _0300_ VGND VGND VPWR VPWR net168 sky130_fd_sc_hd__buf_2
XFILLER_30_409 VGND VGND VPWR VPWR sky130_fd_sc_hd__decap_8
XFILLER_2_365 VPWR VGND VPWR VGND sky130_ef_sc_hd__decap_12
XFILLER_2_321 VPWR VGND VPWR VGND sky130_ef_sc_hd__decap_12
XFILLER_73_361 VPWR VGND VPWR VGND sky130_ef_sc_hd__decap_12
XTAP_TAPCELL_ROW_48_548 VGND VPWR sky130_fd_sc_hd__tapvpwrvgnd_1
XFILLER_18_277 VGND VGND VPWR VPWR sky130_fd_sc_hd__fill_2
X_0911_ scratch\[4\]\[11\] net228 net219 scratch\[5\]\[11\] net233 VGND VGND VPWR
+ VPWR _0662_ sky130_fd_sc_hd__a221o_1
XTAP_TAPCELL_ROW_31_415 VGND VPWR sky130_fd_sc_hd__tapvpwrvgnd_1
X_1891_ clknet_leaf_24_clock _0233_ VGND VGND VPWR VPWR scratch\[3\]\[30\] sky130_fd_sc_hd__dfxtp_1
X_0842_ net69 _0601_ _0603_ _0598_ VGND VGND VPWR VPWR net75 sky130_fd_sc_hd__a211o_1
XFILLER_5_181 VPWR VGND VPWR VGND sky130_ef_sc_hd__decap_12
XFILLER_68_133 VGND VGND VPWR VPWR sky130_fd_sc_hd__decap_6
X_1256_ net49 net161 _0306_ VGND VGND VPWR VPWR _0134_ sky130_fd_sc_hd__a21bo_1
X_1325_ _0582_ net205 _0342_ VGND VGND VPWR VPWR _0167_ sky130_fd_sc_hd__and3b_1
XFILLER_33_17 VGND VGND VPWR VPWR sky130_fd_sc_hd__fill_1
X_1187_ net47 net169 _0271_ VGND VGND VPWR VPWR _0100_ sky130_fd_sc_hd__a21bo_1
XFILLER_59_144 VGND VGND VPWR VPWR sky130_fd_sc_hd__fill_2
XFILLER_59_111 VGND VGND VPWR VPWR sky130_fd_sc_hd__fill_1
XFILLER_62_309 VPWR VGND VPWR VGND sky130_ef_sc_hd__decap_12
XTAP_TAPCELL_ROW_53_584 VGND VPWR sky130_fd_sc_hd__tapvpwrvgnd_1
XFILLER_23_61 VPWR VGND VPWR VGND sky130_ef_sc_hd__decap_12
XFILLER_23_94 VPWR VGND VPWR VGND sky130_ef_sc_hd__decap_12
X_1110_ net34 net186 net129 net351 VGND VGND VPWR VPWR _0053_ sky130_fd_sc_hd__a22o_1
XFILLER_2_195 VGND VGND VPWR VPWR sky130_fd_sc_hd__fill_1
XFILLER_65_169 VGND VGND VPWR VPWR sky130_fd_sc_hd__decap_3
X_1041_ net236 net16 net15 net18 VGND VGND VPWR VPWR _0771_ sky130_fd_sc_hd__or4_1
XFILLER_9_30 VPWR VGND VPWR VGND sky130_ef_sc_hd__decap_12
X_1874_ clknet_leaf_24_clock _0216_ VGND VGND VPWR VPWR scratch\[3\]\[13\] sky130_fd_sc_hd__dfxtp_1
X_0825_ net263 net253 VGND VGND VPWR VPWR _0587_ sky130_fd_sc_hd__nor2_1
XFILLER_9_85 VGND VGND VPWR VPWR sky130_fd_sc_hd__fill_1
XTAP_TAPCELL_ROW_67_698 VGND VPWR sky130_fd_sc_hd__tapvpwrvgnd_1
XFILLER_44_309 VPWR VGND VPWR VGND sky130_ef_sc_hd__decap_12
XFILLER_37_383 VGND VGND VPWR VPWR sky130_fd_sc_hd__decap_8
X_1239_ net43 net174 _0297_ VGND VGND VPWR VPWR _0126_ sky130_fd_sc_hd__a21bo_1
X_1308_ net46 net160 _0332_ VGND VGND VPWR VPWR _0160_ sky130_fd_sc_hd__a21bo_1
XTAP_TAPCELL_ROW_50_565 VGND VPWR sky130_fd_sc_hd__tapvpwrvgnd_1
XFILLER_12_228 VGND VGND VPWR VPWR sky130_fd_sc_hd__fill_1
XFILLER_69_57 VPWR VGND VPWR VGND sky130_ef_sc_hd__decap_12
XFILLER_20_283 VPWR VGND VPWR VGND sky130_ef_sc_hd__decap_12
XFILLER_75_445 VGND VGND VPWR VPWR sky130_fd_sc_hd__decap_3
XTAP_TAPCELL_ROW_7_221 VGND VPWR sky130_fd_sc_hd__tapvpwrvgnd_1
XFILLER_28_350 VPWR VGND VPWR VGND sky130_ef_sc_hd__decap_12
XTAP_TAPCELL_ROW_13_267 VGND VPWR sky130_fd_sc_hd__tapvpwrvgnd_1
X_1590_ net199 _0520_ _0521_ VGND VGND VPWR VPWR _0522_ sky130_fd_sc_hd__and3_1
XFILLER_66_445 VGND VGND VPWR VPWR sky130_fd_sc_hd__decap_8
X_1024_ scratch\[0\]\[30\] scratch\[2\]\[30\] scratch\[1\]\[30\] scratch\[3\]\[30\]
+ net257 net267 VGND VGND VPWR VPWR _0756_ sky130_fd_sc_hd__mux4_1
XFILLER_19_350 VPWR VGND VPWR VGND sky130_ef_sc_hd__decap_12
XTAP_TAPCELL_ROW_64_679 VGND VPWR sky130_fd_sc_hd__tapvpwrvgnd_1
XFILLER_61_194 VGND VGND VPWR VPWR sky130_fd_sc_hd__fill_1
X_1857_ clknet_leaf_23_clock _0199_ VGND VGND VPWR VPWR scratch\[0\]\[28\] sky130_fd_sc_hd__dfxtp_1
XFILLER_30_29 VPWR VGND VPWR VGND sky130_ef_sc_hd__decap_12
X_1788_ clknet_leaf_28_clock _0131_ VGND VGND VPWR VPWR scratch\[7\]\[2\] sky130_fd_sc_hd__dfxtp_1
XPHY_EDGE_ROW_12_Left_88 VGND VGND VPWR VPWR sky130_fd_sc_hd__decap_3
XTAP_TAPCELL_ROW_55_602 VGND VPWR sky130_fd_sc_hd__tapvpwrvgnd_1
XFILLER_44_139 VGND VGND VPWR VPWR sky130_fd_sc_hd__fill_1
XFILLER_29_169 VGND VGND VPWR VPWR sky130_fd_sc_hd__decap_4
XFILLER_71_69 VPWR VGND VPWR VGND sky130_ef_sc_hd__decap_12
XFILLER_20_73 VGND VGND VPWR VPWR sky130_fd_sc_hd__fill_2
XFILLER_75_297 VGND VGND VPWR VPWR sky130_fd_sc_hd__decap_3
Xhold71 scratch\[5\]\[5\] VGND VGND VPWR VPWR net347 sky130_fd_sc_hd__dlygate4sd3_1
XFILLER_35_117 VGND VGND VPWR VPWR sky130_fd_sc_hd__fill_1
Xhold60 scratch\[4\]\[30\] VGND VGND VPWR VPWR net336 sky130_fd_sc_hd__dlygate4sd3_1
Xhold82 scratch\[4\]\[24\] VGND VGND VPWR VPWR net358 sky130_fd_sc_hd__dlygate4sd3_1
XTAP_TAPCELL_ROW_18_304 VGND VPWR sky130_fd_sc_hd__tapvpwrvgnd_1
Xhold93 scratch\[4\]\[25\] VGND VGND VPWR VPWR net369 sky130_fd_sc_hd__dlygate4sd3_1
XTAP_TAPCELL_ROW_61_649 VGND VPWR sky130_fd_sc_hd__tapvpwrvgnd_1
XFILLER_28_191 VGND VGND VPWR VPWR sky130_fd_sc_hd__decap_4
XTAP_TAPCELL_ROW_26_370 VGND VPWR sky130_fd_sc_hd__tapvpwrvgnd_1
X_1711_ clknet_leaf_13_clock _0054_ VGND VGND VPWR VPWR scratch\[5\]\[21\] sky130_fd_sc_hd__dfxtp_1
XANTENNA_2 net7 VGND VGND VPWR VPWR sky130_fd_sc_hd__diode_2
X_1642_ net306 net109 _0563_ VGND VGND VPWR VPWR _0263_ sky130_fd_sc_hd__a21o_1
XFILLER_6_53 VPWR VGND VPWR VGND sky130_ef_sc_hd__decap_12
XTAP_TAPCELL_ROW_69_716 VGND VPWR sky130_fd_sc_hd__tapvpwrvgnd_1
XFILLER_66_220 VPWR VGND VPWR VGND sky130_ef_sc_hd__decap_12
X_1573_ scratch\[3\]\[15\] scratch\[2\]\[15\] VGND VGND VPWR VPWR _0508_ sky130_fd_sc_hd__nand2_1
XFILLER_6_97 VPWR VGND VPWR VGND sky130_ef_sc_hd__decap_12
XFILLER_66_253 VPWR VGND VPWR VGND sky130_ef_sc_hd__decap_12
X_1007_ scratch\[4\]\[27\] net227 net218 scratch\[5\]\[27\] net234 VGND VGND VPWR
+ VPWR _0742_ sky130_fd_sc_hd__a221o_1
X_1909_ clknet_leaf_16_clock _0251_ VGND VGND VPWR VPWR scratch\[1\]\[16\] sky130_fd_sc_hd__dfxtp_1
XFILLER_22_312 VGND VGND VPWR VPWR sky130_fd_sc_hd__fill_2
XFILLER_1_205 VPWR VGND VPWR VGND sky130_ef_sc_hd__decap_12
XFILLER_1_249 VPWR VGND VPWR VGND sky130_ef_sc_hd__decap_12
XFILLER_72_289 VPWR VGND VPWR VGND sky130_ef_sc_hd__decap_12
XFILLER_72_245 VGND VGND VPWR VPWR sky130_fd_sc_hd__decap_6
XFILLER_60_418 VGND VGND VPWR VPWR sky130_fd_sc_hd__fill_2
XFILLER_32_109 VGND VGND VPWR VPWR sky130_fd_sc_hd__decap_8
XFILLER_17_139 VGND VGND VPWR VPWR sky130_fd_sc_hd__fill_2
XFILLER_40_164 VPWR VGND VPWR VGND sky130_ef_sc_hd__decap_12
XTAP_TAPCELL_ROW_23_351 VGND VPWR sky130_fd_sc_hd__tapvpwrvgnd_1
XFILLER_9_349 VPWR VGND VPWR VGND sky130_ef_sc_hd__decap_12
Xoutput83 net83 VGND VGND VPWR VPWR host_output_data[17] sky130_fd_sc_hd__buf_2
Xoutput94 net94 VGND VGND VPWR VPWR host_output_data[27] sky130_fd_sc_hd__buf_2
Xoutput72 net72 VGND VGND VPWR VPWR current_stage[3] sky130_fd_sc_hd__clkbuf_4
XTAP_TAPCELL_ROW_74_752 VGND VPWR sky130_fd_sc_hd__tapvpwrvgnd_1
XFILLER_63_234 VGND VGND VPWR VPWR sky130_fd_sc_hd__decap_8
XFILLER_56_91 VGND VGND VPWR VPWR sky130_fd_sc_hd__fill_1
XFILLER_56_80 VGND VGND VPWR VPWR sky130_fd_sc_hd__decap_4
XFILLER_48_286 VPWR VGND VPWR VGND sky130_ef_sc_hd__decap_12
XFILLER_48_253 VGND VGND VPWR VPWR sky130_fd_sc_hd__decap_8
XFILLER_48_242 VGND VGND VPWR VPWR sky130_fd_sc_hd__fill_2
XFILLER_36_448 VGND VGND VPWR VPWR sky130_fd_sc_hd__fill_1
X_1556_ net24 _0494_ net140 VGND VGND VPWR VPWR _0495_ sky130_fd_sc_hd__mux2_1
X_1625_ net199 _0548_ _0549_ VGND VGND VPWR VPWR _0550_ sky130_fd_sc_hd__and3_1
XFILLER_54_212 VPWR VGND VPWR VGND sky130_ef_sc_hd__decap_12
Xclkbuf_2_3__f_clock clknet_0_clock VGND VGND VPWR VPWR clknet_2_3__leaf_clock sky130_fd_sc_hd__clkbuf_16
X_1487_ net37 net146 net116 net398 VGND VGND VPWR VPWR _0226_ sky130_fd_sc_hd__a22o_1
XFILLER_50_451 VGND VGND VPWR VPWR sky130_fd_sc_hd__fill_2
XFILLER_52_49 VGND VGND VPWR VPWR sky130_fd_sc_hd__fill_1
XFILLER_22_175 VGND VGND VPWR VPWR sky130_fd_sc_hd__decap_4
XFILLER_10_337 VPWR VGND VPWR VGND sky130_ef_sc_hd__decap_12
XTAP_TAPCELL_ROW_20_321 VGND VPWR sky130_fd_sc_hd__tapvpwrvgnd_1
XPHY_EDGE_ROW_15_Left_91 VGND VGND VPWR VPWR sky130_fd_sc_hd__decap_3
XTAP_TAPCELL_ROW_71_733 VGND VPWR sky130_fd_sc_hd__tapvpwrvgnd_1
XFILLER_42_71 VPWR VGND VPWR VGND sky130_ef_sc_hd__decap_12
XFILLER_41_440 VGND VGND VPWR VPWR sky130_fd_sc_hd__decap_4
XFILLER_26_83 VGND VGND VPWR VPWR sky130_fd_sc_hd__fill_1
XFILLER_26_72 VGND VGND VPWR VPWR sky130_fd_sc_hd__decap_4
XFILLER_13_142 VGND VGND VPWR VPWR sky130_fd_sc_hd__fill_1
XFILLER_13_153 VGND VGND VPWR VPWR sky130_fd_sc_hd__decap_3
X_1410_ net31 net158 net118 _0405_ VGND VGND VPWR VPWR _0189_ sky130_fd_sc_hd__a22o_1
XFILLER_5_385 VGND VGND VPWR VPWR sky130_fd_sc_hd__decap_6
X_1272_ net26 net159 _0314_ VGND VGND VPWR VPWR _0142_ sky130_fd_sc_hd__a21bo_1
X_1341_ net194 _0351_ _0352_ _0353_ VGND VGND VPWR VPWR _0172_ sky130_fd_sc_hd__a31o_1
XFILLER_36_267 VGND VGND VPWR VPWR sky130_fd_sc_hd__fill_1
XFILLER_36_234 VGND VGND VPWR VPWR sky130_fd_sc_hd__decap_6
XTAP_TAPCELL_ROW_34_435 VGND VPWR sky130_fd_sc_hd__tapvpwrvgnd_1
XFILLER_24_418 VGND VGND VPWR VPWR sky130_fd_sc_hd__fill_2
X_0987_ net252 _0722_ _0725_ net210 VGND VGND VPWR VPWR net90 sky130_fd_sc_hd__o211a_1
XFILLER_59_337 VGND VGND VPWR VPWR sky130_fd_sc_hd__decap_6
X_1539_ scratch\[3\]\[8\] scratch\[2\]\[8\] VGND VGND VPWR VPWR _0481_ sky130_fd_sc_hd__or2_1
Xfanout147 net149 VGND VGND VPWR VPWR net147 sky130_fd_sc_hd__clkbuf_2
Xfanout136 _0783_ VGND VGND VPWR VPWR net136 sky130_fd_sc_hd__clkbuf_2
Xfanout114 net115 VGND VGND VPWR VPWR net114 sky130_fd_sc_hd__buf_2
X_1608_ scratch\[3\]\[22\] scratch\[2\]\[22\] VGND VGND VPWR VPWR _0536_ sky130_fd_sc_hd__nand2_1
Xfanout125 net126 VGND VGND VPWR VPWR net125 sky130_fd_sc_hd__clkbuf_4
XFILLER_74_307 VGND VGND VPWR VPWR sky130_fd_sc_hd__fill_1
XFILLER_63_15 VPWR VGND VPWR VGND sky130_ef_sc_hd__decap_12
XFILLER_47_16 VGND VGND VPWR VPWR sky130_fd_sc_hd__fill_2
Xfanout158 _0346_ VGND VGND VPWR VPWR net158 sky130_fd_sc_hd__clkbuf_2
Xfanout169 net173 VGND VGND VPWR VPWR net169 sky130_fd_sc_hd__buf_2
XFILLER_42_215 VPWR VGND VPWR VGND sky130_ef_sc_hd__decap_12
XFILLER_27_289 VGND VGND VPWR VPWR sky130_fd_sc_hd__decap_6
XFILLER_12_85 VGND VGND VPWR VPWR sky130_fd_sc_hd__decap_6
XFILLER_2_377 VPWR VGND VPWR VGND sky130_ef_sc_hd__decap_12
XFILLER_2_333 VPWR VGND VPWR VGND sky130_ef_sc_hd__decap_12
XPHY_EDGE_ROW_0_Left_76 VGND VGND VPWR VPWR sky130_fd_sc_hd__decap_3
XFILLER_18_201 VGND VGND VPWR VPWR sky130_fd_sc_hd__fill_1
XFILLER_73_373 VPWR VGND VPWR VGND sky130_ef_sc_hd__decap_12
XFILLER_58_392 VPWR VGND VPWR VGND sky130_ef_sc_hd__decap_12
XTAP_TAPCELL_ROW_48_549 VGND VPWR sky130_fd_sc_hd__tapvpwrvgnd_1
XPHY_EDGE_ROW_16_Right_16 VGND VGND VPWR VPWR sky130_fd_sc_hd__decap_3
X_0910_ scratch\[6\]\[11\] scratch\[7\]\[11\] net271 VGND VGND VPWR VPWR _0661_ sky130_fd_sc_hd__mux2_1
XFILLER_41_281 VGND VGND VPWR VPWR sky130_fd_sc_hd__decap_4
XPHY_EDGE_ROW_25_Right_25 VGND VGND VPWR VPWR sky130_fd_sc_hd__decap_3
X_1890_ clknet_leaf_23_clock _0232_ VGND VGND VPWR VPWR scratch\[3\]\[29\] sky130_fd_sc_hd__dfxtp_1
X_0841_ net206 _0600_ _0602_ net74 VGND VGND VPWR VPWR _0603_ sky130_fd_sc_hd__and4b_1
XFILLER_5_193 VPWR VGND VPWR VGND sky130_ef_sc_hd__decap_12
XFILLER_64_362 VGND VGND VPWR VPWR sky130_fd_sc_hd__fill_2
XFILLER_56_307 VGND VGND VPWR VPWR sky130_fd_sc_hd__fill_1
XFILLER_49_370 VGND VGND VPWR VPWR sky130_fd_sc_hd__decap_4
X_1255_ net241 net161 scratch\[7\]\[5\] VGND VGND VPWR VPWR _0306_ sky130_fd_sc_hd__or3b_1
XPHY_EDGE_ROW_34_Right_34 VGND VGND VPWR VPWR sky130_fd_sc_hd__decap_3
X_1324_ net212 cycle_count\[0\] cycle_count\[1\] VGND VGND VPWR VPWR _0342_ sky130_fd_sc_hd__a21o_1
X_1186_ net237 net169 scratch\[6\]\[3\] VGND VGND VPWR VPWR _0271_ sky130_fd_sc_hd__or3b_1
XPHY_EDGE_ROW_43_Right_43 VGND VGND VPWR VPWR sky130_fd_sc_hd__decap_3
XFILLER_59_167 VGND VGND VPWR VPWR sky130_fd_sc_hd__fill_1
XFILLER_58_15 VPWR VGND VPWR VGND sky130_ef_sc_hd__decap_12
XPHY_EDGE_ROW_52_Right_52 VGND VGND VPWR VPWR sky130_fd_sc_hd__decap_3
XFILLER_70_321 VPWR VGND VPWR VGND sky130_ef_sc_hd__decap_12
XFILLER_55_373 VGND VGND VPWR VPWR sky130_fd_sc_hd__fill_1
XPHY_EDGE_ROW_27_Left_103 VGND VGND VPWR VPWR sky130_fd_sc_hd__decap_3
XFILLER_70_365 VPWR VGND VPWR VGND sky130_ef_sc_hd__decap_12
XPHY_EDGE_ROW_61_Right_61 VGND VGND VPWR VPWR sky130_fd_sc_hd__decap_3
XTAP_TAPCELL_ROW_53_585 VGND VPWR sky130_fd_sc_hd__tapvpwrvgnd_1
XPHY_EDGE_ROW_36_Left_112 VGND VGND VPWR VPWR sky130_fd_sc_hd__decap_3
XFILLER_23_281 VGND VGND VPWR VPWR sky130_fd_sc_hd__decap_8
XFILLER_23_73 VGND VGND VPWR VPWR sky130_fd_sc_hd__decap_6
XFILLER_7_447 VGND VGND VPWR VPWR sky130_fd_sc_hd__fill_1
XPHY_EDGE_ROW_70_Right_70 VGND VGND VPWR VPWR sky130_fd_sc_hd__decap_3
XFILLER_2_141 VPWR VGND VPWR VGND sky130_ef_sc_hd__decap_12
XFILLER_65_137 VGND VGND VPWR VPWR sky130_fd_sc_hd__decap_3
X_1040_ net17 net20 net19 net2 VGND VGND VPWR VPWR _0770_ sky130_fd_sc_hd__or4_1
XPHY_EDGE_ROW_45_Left_121 VGND VGND VPWR VPWR sky130_fd_sc_hd__decap_3
XFILLER_73_181 VPWR VGND VPWR VGND sky130_ef_sc_hd__decap_12
XFILLER_9_42 VPWR VGND VPWR VGND sky130_ef_sc_hd__decap_12
X_1873_ clknet_leaf_11_clock _0215_ VGND VGND VPWR VPWR scratch\[3\]\[12\] sky130_fd_sc_hd__dfxtp_1
XPHY_EDGE_ROW_54_Left_130 VGND VGND VPWR VPWR sky130_fd_sc_hd__decap_3
X_0824_ scratch\[2\]\[0\] scratch\[3\]\[0\] net263 VGND VGND VPWR VPWR _0586_ sky130_fd_sc_hd__mux2_1
XFILLER_28_29 VGND VGND VPWR VPWR sky130_fd_sc_hd__decap_4
XTAP_TAPCELL_ROW_67_699 VGND VPWR sky130_fd_sc_hd__tapvpwrvgnd_1
XFILLER_52_321 VGND VGND VPWR VPWR sky130_fd_sc_hd__fill_2
X_1169_ net381 net124 _0807_ VGND VGND VPWR VPWR _0092_ sky130_fd_sc_hd__a21o_1
XFILLER_29_329 VGND VGND VPWR VPWR sky130_fd_sc_hd__decap_6
X_1238_ net244 net174 scratch\[6\]\[29\] VGND VGND VPWR VPWR _0297_ sky130_fd_sc_hd__or3b_1
X_1307_ net237 net160 scratch\[7\]\[31\] VGND VGND VPWR VPWR _0332_ sky130_fd_sc_hd__or3b_1
XFILLER_60_27 VGND VGND VPWR VPWR sky130_fd_sc_hd__fill_1
XFILLER_52_365 VPWR VGND VPWR VGND sky130_ef_sc_hd__decap_12
XTAP_TAPCELL_ROW_50_566 VGND VPWR sky130_fd_sc_hd__tapvpwrvgnd_1
XFILLER_69_69 VPWR VGND VPWR VGND sky130_ef_sc_hd__decap_12
XTAP_TAPCELL_ROW_7_222 VGND VPWR sky130_fd_sc_hd__tapvpwrvgnd_1
XFILLER_20_295 VPWR VGND VPWR VGND sky130_ef_sc_hd__decap_12
XFILLER_70_195 VGND VGND VPWR VPWR sky130_fd_sc_hd__fill_1
XFILLER_28_395 VGND VGND VPWR VPWR sky130_fd_sc_hd__fill_1
XFILLER_28_362 VGND VGND VPWR VPWR sky130_fd_sc_hd__fill_2
XFILLER_50_93 VGND VGND VPWR VPWR sky130_fd_sc_hd__fill_1
XFILLER_34_83 VGND VGND VPWR VPWR sky130_fd_sc_hd__fill_1
XFILLER_11_273 VGND VGND VPWR VPWR sky130_fd_sc_hd__decap_6
XTAP_TAPCELL_ROW_13_268 VGND VPWR sky130_fd_sc_hd__tapvpwrvgnd_1
XFILLER_46_181 VPWR VGND VPWR VGND sky130_ef_sc_hd__decap_12
XFILLER_38_137 VGND VGND VPWR VPWR sky130_fd_sc_hd__decap_3
X_1023_ net208 _0752_ _0755_ VGND VGND VPWR VPWR net96 sky130_fd_sc_hd__and3_1
XFILLER_19_362 VGND VGND VPWR VPWR sky130_fd_sc_hd__decap_6
XFILLER_19_384 VGND VGND VPWR VPWR sky130_fd_sc_hd__decap_8
XFILLER_34_365 VGND VGND VPWR VPWR sky130_fd_sc_hd__fill_1
X_1856_ clknet_leaf_17_clock _0198_ VGND VGND VPWR VPWR scratch\[0\]\[27\] sky130_fd_sc_hd__dfxtp_1
X_1787_ clknet_leaf_27_clock _0130_ VGND VGND VPWR VPWR scratch\[7\]\[1\] sky130_fd_sc_hd__dfxtp_1
XPHY_EDGE_ROW_2_Right_2 VGND VGND VPWR VPWR sky130_fd_sc_hd__decap_3
XFILLER_71_15 VPWR VGND VPWR VGND sky130_ef_sc_hd__decap_12
XTAP_TAPCELL_ROW_55_603 VGND VPWR sky130_fd_sc_hd__tapvpwrvgnd_1
XFILLER_44_107 VPWR VGND VPWR VGND sky130_ef_sc_hd__decap_12
XFILLER_37_192 VPWR VGND VPWR VGND sky130_ef_sc_hd__decap_12
XFILLER_75_276 VGND VGND VPWR VPWR sky130_fd_sc_hd__decap_4
XFILLER_75_221 VGND VGND VPWR VPWR sky130_fd_sc_hd__decap_3
XFILLER_63_449 VGND VGND VPWR VPWR sky130_fd_sc_hd__decap_4
XFILLER_63_405 VPWR VGND VPWR VGND sky130_ef_sc_hd__decap_12
Xhold61 scratch\[4\]\[23\] VGND VGND VPWR VPWR net337 sky130_fd_sc_hd__dlygate4sd3_1
Xhold72 scratch\[4\]\[22\] VGND VGND VPWR VPWR net348 sky130_fd_sc_hd__dlygate4sd3_1
XTAP_TAPCELL_ROW_18_305 VGND VPWR sky130_fd_sc_hd__tapvpwrvgnd_1
Xhold94 scratch\[5\]\[24\] VGND VGND VPWR VPWR net370 sky130_fd_sc_hd__dlygate4sd3_1
Xhold50 scratch\[5\]\[1\] VGND VGND VPWR VPWR net326 sky130_fd_sc_hd__dlygate4sd3_1
Xhold83 scratch\[5\]\[28\] VGND VGND VPWR VPWR net359 sky130_fd_sc_hd__dlygate4sd3_1
XFILLER_31_335 VGND VGND VPWR VPWR sky130_fd_sc_hd__fill_1
XTAP_TAPCELL_ROW_26_371 VGND VPWR sky130_fd_sc_hd__tapvpwrvgnd_1
XFILLER_16_365 VPWR VGND VPWR VGND sky130_ef_sc_hd__decap_12
X_1572_ net284 net107 _0507_ VGND VGND VPWR VPWR _0249_ sky130_fd_sc_hd__a21o_1
X_1710_ clknet_leaf_13_clock _0053_ VGND VGND VPWR VPWR scratch\[5\]\[20\] sky130_fd_sc_hd__dfxtp_1
XANTENNA_3 net126 VGND VGND VPWR VPWR sky130_fd_sc_hd__diode_2
X_1641_ net42 _0562_ net139 VGND VGND VPWR VPWR _0563_ sky130_fd_sc_hd__mux2_1
XFILLER_6_65 VPWR VGND VPWR VGND sky130_ef_sc_hd__decap_12
XTAP_TAPCELL_ROW_69_717 VGND VPWR sky130_fd_sc_hd__tapvpwrvgnd_1
XFILLER_66_232 VGND VGND VPWR VPWR sky130_fd_sc_hd__decap_6
XFILLER_66_265 VGND VGND VPWR VPWR sky130_fd_sc_hd__decap_6
X_1006_ scratch\[6\]\[27\] scratch\[7\]\[27\] net270 VGND VGND VPWR VPWR _0741_ sky130_fd_sc_hd__mux2_1
X_1839_ clknet_leaf_8_clock _0181_ VGND VGND VPWR VPWR scratch\[0\]\[10\] sky130_fd_sc_hd__dfxtp_1
X_1908_ clknet_leaf_24_clock _0250_ VGND VGND VPWR VPWR scratch\[1\]\[15\] sky130_fd_sc_hd__dfxtp_1
XFILLER_34_195 VGND VGND VPWR VPWR sky130_fd_sc_hd__fill_1
XFILLER_1_217 VGND VGND VPWR VPWR sky130_fd_sc_hd__decap_6
XFILLER_66_15 VPWR VGND VPWR VGND sky130_ef_sc_hd__decap_12
XFILLER_45_449 VGND VGND VPWR VPWR sky130_fd_sc_hd__decap_4
XFILLER_40_176 VGND VGND VPWR VPWR sky130_fd_sc_hd__decap_4
XFILLER_40_132 VGND VGND VPWR VPWR sky130_fd_sc_hd__decap_8
XFILLER_13_335 VGND VGND VPWR VPWR sky130_fd_sc_hd__fill_1
XFILLER_48_210 VGND VGND VPWR VPWR sky130_fd_sc_hd__decap_4
Xoutput84 net84 VGND VGND VPWR VPWR host_output_data[18] sky130_fd_sc_hd__buf_2
Xoutput73 net73 VGND VGND VPWR VPWR current_stage[4] sky130_fd_sc_hd__clkbuf_4
Xoutput95 net95 VGND VGND VPWR VPWR host_output_data[28] sky130_fd_sc_hd__buf_2
XTAP_TAPCELL_ROW_74_753 VGND VPWR sky130_fd_sc_hd__tapvpwrvgnd_1
XFILLER_63_202 VGND VGND VPWR VPWR sky130_fd_sc_hd__decap_4
XFILLER_48_298 VGND VGND VPWR VPWR sky130_fd_sc_hd__decap_8
XFILLER_48_265 VGND VGND VPWR VPWR sky130_fd_sc_hd__fill_1
XFILLER_75_3 VPWR VGND VPWR VGND sky130_ef_sc_hd__decap_12
X_1555_ net201 _0492_ _0493_ VGND VGND VPWR VPWR _0494_ sky130_fd_sc_hd__and3_1
X_1624_ scratch\[3\]\[25\] scratch\[2\]\[25\] VGND VGND VPWR VPWR _0549_ sky130_fd_sc_hd__or2_1
XFILLER_54_224 VGND VGND VPWR VPWR sky130_fd_sc_hd__decap_8
XFILLER_36_29 VPWR VGND VPWR VGND sky130_ef_sc_hd__decap_12
X_1486_ net36 net144 net114 net431 VGND VGND VPWR VPWR _0225_ sky130_fd_sc_hd__a22o_1
XFILLER_54_257 VGND VGND VPWR VPWR sky130_fd_sc_hd__fill_1
XFILLER_42_419 VGND VGND VPWR VPWR sky130_fd_sc_hd__fill_1
XFILLER_6_309 VPWR VGND VPWR VGND sky130_ef_sc_hd__decap_12
XFILLER_10_349 VPWR VGND VPWR VGND sky130_ef_sc_hd__decap_12
XTAP_TAPCELL_ROW_20_322 VGND VPWR sky130_fd_sc_hd__tapvpwrvgnd_1
XFILLER_7_6 VPWR VGND VPWR VGND sky130_ef_sc_hd__decap_12
XTAP_TAPCELL_ROW_71_734 VGND VPWR sky130_fd_sc_hd__tapvpwrvgnd_1
XFILLER_42_83 VGND VGND VPWR VPWR sky130_fd_sc_hd__fill_1
XFILLER_9_169 VPWR VGND VPWR VGND sky130_ef_sc_hd__decap_12
XFILLER_13_187 VPWR VGND VPWR VGND sky130_ef_sc_hd__decap_12
XFILLER_47_7 VGND VGND VPWR VPWR sky130_fd_sc_hd__fill_1
X_1340_ net33 _0347_ _0348_ scratch\[0\]\[1\] VGND VGND VPWR VPWR _0353_ sky130_fd_sc_hd__a22o_1
XFILLER_68_338 VGND VGND VPWR VPWR sky130_fd_sc_hd__fill_1
X_1271_ net240 net159 scratch\[7\]\[13\] VGND VGND VPWR VPWR _0314_ sky130_fd_sc_hd__or3b_1
XFILLER_3_55 VGND VGND VPWR VPWR sky130_fd_sc_hd__fill_1
XTAP_TAPCELL_ROW_34_436 VGND VPWR sky130_fd_sc_hd__tapvpwrvgnd_1
X_0986_ net260 _0723_ _0724_ VGND VGND VPWR VPWR _0725_ sky130_fd_sc_hd__a21o_1
XFILLER_59_349 VGND VGND VPWR VPWR sky130_fd_sc_hd__fill_2
X_1538_ scratch\[3\]\[8\] scratch\[2\]\[8\] VGND VGND VPWR VPWR _0480_ sky130_fd_sc_hd__nand2_1
X_1469_ net49 net143 net113 net436 VGND VGND VPWR VPWR _0208_ sky130_fd_sc_hd__a22o_1
X_1607_ net294 net111 _0535_ VGND VGND VPWR VPWR _0256_ sky130_fd_sc_hd__a21o_1
Xfanout148 net149 VGND VGND VPWR VPWR net148 sky130_fd_sc_hd__buf_1
Xfanout159 net163 VGND VGND VPWR VPWR net159 sky130_fd_sc_hd__buf_2
Xfanout115 net116 VGND VGND VPWR VPWR net115 sky130_fd_sc_hd__clkbuf_4
Xfanout137 net141 VGND VGND VPWR VPWR net137 sky130_fd_sc_hd__clkbuf_4
Xfanout126 _0790_ VGND VGND VPWR VPWR net126 sky130_fd_sc_hd__clkbuf_4
XFILLER_67_393 VPWR VGND VPWR VGND sky130_ef_sc_hd__decap_12
XFILLER_63_27 VPWR VGND VPWR VGND sky130_ef_sc_hd__decap_12
XFILLER_42_227 VGND VGND VPWR VPWR sky130_fd_sc_hd__decap_6
XFILLER_10_102 VPWR VGND VPWR VGND sky130_ef_sc_hd__decap_12
XFILLER_2_345 VPWR VGND VPWR VGND sky130_ef_sc_hd__decap_12
XFILLER_2_301 VGND VGND VPWR VPWR sky130_fd_sc_hd__decap_6
XFILLER_6_139 VGND VGND VPWR VPWR sky130_fd_sc_hd__fill_1
XFILLER_2_389 VPWR VGND VPWR VGND sky130_ef_sc_hd__decap_12
XFILLER_73_385 VGND VGND VPWR VPWR sky130_fd_sc_hd__decap_6
XFILLER_33_216 VGND VGND VPWR VPWR sky130_fd_sc_hd__fill_1
XFILLER_14_452 VGND VGND VPWR VPWR sky130_fd_sc_hd__fill_1
X_0840_ _0589_ _0592_ _0599_ VGND VGND VPWR VPWR _0602_ sky130_fd_sc_hd__nor3_1
X_1323_ net212 net438 _0341_ VGND VGND VPWR VPWR _0166_ sky130_fd_sc_hd__o21a_1
XFILLER_5_161 VGND VGND VPWR VPWR sky130_fd_sc_hd__decap_6
XFILLER_49_393 VPWR VGND VPWR VGND sky130_ef_sc_hd__decap_12
X_1254_ net48 net162 _0305_ VGND VGND VPWR VPWR _0133_ sky130_fd_sc_hd__a21bo_1
XFILLER_24_227 VGND VGND VPWR VPWR sky130_fd_sc_hd__fill_2
X_1185_ net44 net169 _0270_ VGND VGND VPWR VPWR _0099_ sky130_fd_sc_hd__a21bo_1
XFILLER_20_444 VGND VGND VPWR VPWR sky130_fd_sc_hd__decap_4
X_0969_ scratch\[2\]\[21\] scratch\[3\]\[21\] net272 VGND VGND VPWR VPWR _0710_ sky130_fd_sc_hd__mux2_1
XFILLER_74_15 VPWR VGND VPWR VGND sky130_ef_sc_hd__decap_12
XFILLER_58_27 VGND VGND VPWR VPWR sky130_fd_sc_hd__fill_1
XFILLER_70_377 VPWR VGND VPWR VGND sky130_ef_sc_hd__decap_12
XFILLER_70_333 VPWR VGND VPWR VGND sky130_ef_sc_hd__decap_12
XFILLER_15_205 VGND VGND VPWR VPWR sky130_fd_sc_hd__fill_1
XTAP_TAPCELL_ROW_53_586 VGND VPWR sky130_fd_sc_hd__tapvpwrvgnd_1
XFILLER_2_197 VPWR VGND VPWR VGND sky130_ef_sc_hd__decap_12
XFILLER_2_153 VPWR VGND VPWR VGND sky130_ef_sc_hd__decap_12
XFILLER_65_105 VGND VGND VPWR VPWR sky130_fd_sc_hd__decap_6
XFILLER_48_93 VGND VGND VPWR VPWR sky130_fd_sc_hd__fill_2
XFILLER_24_9 VGND VGND VPWR VPWR sky130_fd_sc_hd__fill_1
XFILLER_73_193 VPWR VGND VPWR VGND sky130_ef_sc_hd__decap_12
X_1872_ clknet_leaf_12_clock _0214_ VGND VGND VPWR VPWR scratch\[3\]\[11\] sky130_fd_sc_hd__dfxtp_1
XFILLER_61_333 VGND VGND VPWR VPWR sky130_fd_sc_hd__decap_3
XFILLER_0_89 VGND VGND VPWR VPWR sky130_fd_sc_hd__fill_1
XFILLER_9_54 VGND VGND VPWR VPWR sky130_fd_sc_hd__fill_2
XTAP_TAPCELL_ROW_16_288 VGND VPWR sky130_fd_sc_hd__tapvpwrvgnd_1
X_0823_ _0585_ VGND VGND VPWR VPWR _0000_ sky130_fd_sc_hd__inv_2
XFILLER_56_116 VPWR VGND VPWR VGND sky130_ef_sc_hd__decap_12
X_1306_ net45 net160 _0331_ VGND VGND VPWR VPWR _0159_ sky130_fd_sc_hd__a21bo_1
XFILLER_52_377 VGND VGND VPWR VPWR sky130_fd_sc_hd__decap_6
X_1099_ net53 net188 net128 net362 VGND VGND VPWR VPWR _0042_ sky130_fd_sc_hd__a22o_1
X_1168_ net8 net200 net182 net29 VGND VGND VPWR VPWR _0807_ sky130_fd_sc_hd__a22o_1
X_1237_ net42 net174 _0296_ VGND VGND VPWR VPWR _0125_ sky130_fd_sc_hd__a21bo_1
XTAP_TAPCELL_ROW_50_567 VGND VPWR sky130_fd_sc_hd__tapvpwrvgnd_1
XFILLER_20_241 VGND VGND VPWR VPWR sky130_fd_sc_hd__fill_1
XFILLER_69_15 VPWR VGND VPWR VGND sky130_ef_sc_hd__decap_12
XTAP_TAPCELL_ROW_7_223 VGND VPWR sky130_fd_sc_hd__tapvpwrvgnd_1
XFILLER_55_160 VGND VGND VPWR VPWR sky130_fd_sc_hd__decap_8
XFILLER_28_374 VGND VGND VPWR VPWR sky130_fd_sc_hd__decap_4
XFILLER_18_85 VGND VGND VPWR VPWR sky130_fd_sc_hd__decap_6
XFILLER_70_141 VPWR VGND VPWR VGND sky130_ef_sc_hd__decap_12
XFILLER_55_193 VPWR VGND VPWR VGND sky130_ef_sc_hd__decap_12
XFILLER_43_366 VGND VGND VPWR VPWR sky130_fd_sc_hd__fill_2
XFILLER_7_223 VGND VGND VPWR VPWR sky130_fd_sc_hd__fill_1
XTAP_TAPCELL_ROW_13_269 VGND VPWR sky130_fd_sc_hd__tapvpwrvgnd_1
XFILLER_59_81 VPWR VGND VPWR VGND sky130_ef_sc_hd__decap_12
XFILLER_46_193 VGND VGND VPWR VPWR sky130_fd_sc_hd__decap_3
XFILLER_34_355 VGND VGND VPWR VPWR sky130_fd_sc_hd__fill_1
X_1022_ net258 _0753_ _0754_ VGND VGND VPWR VPWR _0755_ sky130_fd_sc_hd__a21o_1
XFILLER_19_374 VGND VGND VPWR VPWR sky130_fd_sc_hd__fill_2
X_1855_ clknet_leaf_17_clock _0197_ VGND VGND VPWR VPWR scratch\[0\]\[26\] sky130_fd_sc_hd__dfxtp_1
X_1924_ clknet_leaf_25_clock _0266_ VGND VGND VPWR VPWR scratch\[1\]\[31\] sky130_fd_sc_hd__dfxtp_1
X_1786_ clknet_leaf_26_clock _0129_ VGND VGND VPWR VPWR scratch\[7\]\[0\] sky130_fd_sc_hd__dfxtp_1
XFILLER_57_447 VGND VGND VPWR VPWR sky130_fd_sc_hd__fill_1
XTAP_TAPCELL_ROW_55_604 VGND VPWR sky130_fd_sc_hd__tapvpwrvgnd_1
XFILLER_55_28 VPWR VGND VPWR VGND sky130_ef_sc_hd__decap_12
XFILLER_44_119 VGND VGND VPWR VPWR sky130_fd_sc_hd__fill_1
XFILLER_29_127 VPWR VGND VPWR VGND sky130_ef_sc_hd__decap_12
XFILLER_71_27 VPWR VGND VPWR VGND sky130_ef_sc_hd__decap_12
XTAP_TAPCELL_ROW_63_670 VGND VPWR sky130_fd_sc_hd__tapvpwrvgnd_1
XFILLER_52_141 VGND VGND VPWR VPWR sky130_fd_sc_hd__decap_8
XPHY_EDGE_ROW_73_Left_149 VGND VGND VPWR VPWR sky130_fd_sc_hd__decap_3
XFILLER_75_200 VGND VGND VPWR VPWR sky130_fd_sc_hd__fill_2
XFILLER_48_403 VGND VGND VPWR VPWR sky130_fd_sc_hd__fill_1
XFILLER_0_421 VPWR VGND VPWR VGND sky130_ef_sc_hd__decap_12
Xhold40 scratch\[4\]\[28\] VGND VGND VPWR VPWR net316 sky130_fd_sc_hd__dlygate4sd3_1
XFILLER_63_417 VPWR VGND VPWR VGND sky130_ef_sc_hd__decap_12
Xhold95 scratch\[5\]\[14\] VGND VGND VPWR VPWR net371 sky130_fd_sc_hd__dlygate4sd3_1
Xhold62 scratch\[4\]\[21\] VGND VGND VPWR VPWR net338 sky130_fd_sc_hd__dlygate4sd3_1
Xhold73 scratch\[4\]\[18\] VGND VGND VPWR VPWR net349 sky130_fd_sc_hd__dlygate4sd3_1
Xhold84 scratch\[4\]\[26\] VGND VGND VPWR VPWR net360 sky130_fd_sc_hd__dlygate4sd3_1
XTAP_TAPCELL_ROW_18_306 VGND VPWR sky130_fd_sc_hd__tapvpwrvgnd_1
Xhold51 scratch\[5\]\[15\] VGND VGND VPWR VPWR net327 sky130_fd_sc_hd__dlygate4sd3_1
XFILLER_61_93 VPWR VGND VPWR VGND sky130_ef_sc_hd__decap_12
XTAP_TAPCELL_ROW_26_372 VGND VPWR sky130_fd_sc_hd__tapvpwrvgnd_1
XFILLER_16_377 VGND VGND VPWR VPWR sky130_fd_sc_hd__decap_3
X_1571_ net27 _0506_ net138 VGND VGND VPWR VPWR _0507_ sky130_fd_sc_hd__mux2_1
XANTENNA_4 net235 VGND VGND VPWR VPWR sky130_fd_sc_hd__diode_2
X_1640_ net198 _0560_ _0561_ VGND VGND VPWR VPWR _0562_ sky130_fd_sc_hd__and3_1
XFILLER_3_281 VPWR VGND VPWR VGND sky130_ef_sc_hd__decap_12
XFILLER_6_77 VGND VGND VPWR VPWR sky130_fd_sc_hd__decap_6
XTAP_TAPCELL_ROW_69_718 VGND VPWR sky130_fd_sc_hd__tapvpwrvgnd_1
XTAP_TAPCELL_ROW_60_640 VGND VPWR sky130_fd_sc_hd__tapvpwrvgnd_1
X_1005_ scratch\[0\]\[27\] scratch\[2\]\[27\] scratch\[1\]\[27\] scratch\[3\]\[27\]
+ net262 net269 VGND VGND VPWR VPWR _0740_ sky130_fd_sc_hd__mux4_1
XFILLER_22_358 VGND VGND VPWR VPWR sky130_fd_sc_hd__decap_6
X_1907_ clknet_leaf_6_clock _0249_ VGND VGND VPWR VPWR scratch\[1\]\[14\] sky130_fd_sc_hd__dfxtp_1
X_1838_ clknet_leaf_8_clock _0180_ VGND VGND VPWR VPWR scratch\[0\]\[9\] sky130_fd_sc_hd__dfxtp_1
XFILLER_66_27 VGND VGND VPWR VPWR sky130_fd_sc_hd__fill_1
X_1769_ clknet_leaf_22_clock _0112_ VGND VGND VPWR VPWR scratch\[6\]\[15\] sky130_fd_sc_hd__dfxtp_1
XFILLER_57_222 VGND VGND VPWR VPWR sky130_fd_sc_hd__fill_2
XFILLER_17_108 VGND VGND VPWR VPWR sky130_fd_sc_hd__decap_4
XFILLER_25_185 VGND VGND VPWR VPWR sky130_fd_sc_hd__fill_2
XFILLER_15_53 VGND VGND VPWR VPWR sky130_fd_sc_hd__decap_3
XFILLER_31_30 VGND VGND VPWR VPWR sky130_fd_sc_hd__fill_1
Xoutput85 net85 VGND VGND VPWR VPWR host_output_data[19] sky130_fd_sc_hd__buf_2
XFILLER_48_277 VGND VGND VPWR VPWR sky130_fd_sc_hd__decap_4
XFILLER_48_222 VGND VGND VPWR VPWR sky130_fd_sc_hd__decap_3
XFILLER_36_417 VGND VGND VPWR VPWR sky130_fd_sc_hd__decap_3
Xoutput96 net96 VGND VGND VPWR VPWR host_output_data[29] sky130_fd_sc_hd__buf_2
XFILLER_0_262 VGND VGND VPWR VPWR sky130_fd_sc_hd__decap_8
Xoutput74 net74 VGND VGND VPWR VPWR done sky130_fd_sc_hd__clkbuf_4
XTAP_TAPCELL_ROW_74_754 VGND VPWR sky130_fd_sc_hd__tapvpwrvgnd_1
XFILLER_63_225 VGND VGND VPWR VPWR sky130_fd_sc_hd__decap_3
XFILLER_31_111 VGND VGND VPWR VPWR sky130_fd_sc_hd__fill_1
XFILLER_68_3 VPWR VGND VPWR VGND sky130_ef_sc_hd__decap_12
XFILLER_31_177 VPWR VGND VPWR VGND sky130_ef_sc_hd__decap_12
XFILLER_31_155 VGND VGND VPWR VPWR sky130_fd_sc_hd__decap_8
X_1554_ scratch\[3\]\[11\] scratch\[2\]\[11\] VGND VGND VPWR VPWR _0493_ sky130_fd_sc_hd__or2_1
X_1485_ net35 net146 net116 net426 VGND VGND VPWR VPWR _0224_ sky130_fd_sc_hd__a22o_1
X_1623_ scratch\[3\]\[25\] scratch\[2\]\[25\] VGND VGND VPWR VPWR _0548_ sky130_fd_sc_hd__nand2_1
.ends
